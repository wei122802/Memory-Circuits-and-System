* 6-to-64 Row Decoder (3 groups of 2-to-4 pre-decoders)

.subckt NAND4 A B C D Y VDD VSS
Mp1 Y A VDD VDD pmos_sram L=2e-08 W=2.7e-08 NFIN=2
Mp2 Y B VDD VDD pmos_sram L=2e-08 W=2.7e-08 NFIN=2
Mp3 Y C VDD VDD pmos_sram L=2e-08 W=2.7e-08 NFIN=2
Mp4 Y D VDD VDD pmos_sram L=2e-08 W=2.7e-08 NFIN=2
Mn1 Y A n1  VSS nmos_sram L=2e-08 W=2.7e-08 NFIN=2
Mn2 n1 B n2  VSS nmos_sram L=2e-08 W=2.7e-08 NFIN=2
Mn3 n2 C n3  VSS nmos_sram L=2e-08 W=2.7e-08 NFIN=2
Mn4 n3 D VSS VSS nmos_sram L=2e-08 W=2.7e-08 NFIN=2
.ends

.subckt PREDEC_2TO4 A B Y0 Y1 Y2 Y3 VDD VSS
X_inv_A A A_b VDD VSS INV_S
X_inv_B B B_b VDD VSS INV_S
X_nd0 A_b B_b Y0_b VDD VSS NAND2
X_inv0 Y0_b Y0 VDD VSS INV_S
X_nd1 A B_b Y1_b VDD VSS NAND2
X_inv1 Y1_b Y1 VDD VSS INV_S
X_nd2 A_b B Y2_b VDD VSS NAND2
X_inv2 Y2_b Y2 VDD VSS INV_S
X_nd3 A B Y3_b VDD VSS NAND2
X_inv3 Y3_b Y3 VDD VSS INV_S
.ends

.subckt ROW_DECODER_3X2TO4 clk A6 A5 A4 A3 A2 A1 WL0 WL1 WL2 WL3 WL4 WL5 WL6 WL7 WL8 WL9 WL10 WL11 WL12 WL13 WL14 WL15 WL16 WL17 WL18 WL19 WL20 WL21 WL22 WL23 WL24 WL25 WL26 WL27 WL28 WL29 WL30 WL31 WL32 WL33 WL34 WL35 WL36 WL37 WL38 WL39 WL40 WL41 WL42 WL43 WL44 WL45 WL46 WL47 WL48 WL49 WL50 WL51 WL52 WL53 WL54 WL55 WL56 WL57 WL58 WL59 WL60 WL61 WL62 WL63 VDD VSS
X_inv_clk_1 clk clk_b VDD VSS INV_S
X_inv_clk_2 clk_b clk_buf VDD VSS INV_S
X_pre0 A1 A2 pre0_0 pre0_1 pre0_2 pre0_3 VDD VSS PREDEC_2TO4
X_pre1 A3 A4 pre1_0 pre1_1 pre1_2 pre1_3 VDD VSS PREDEC_2TO4
X_pre2 A5 A6 pre2_0 pre2_1 pre2_2 pre2_3 VDD VSS PREDEC_2TO4
X_nand4_WL0 clk_buf pre0_0 pre1_0 pre2_0 WL0_nand VDD VSS NAND4
X_buf1_WL0 WL0_nand WL0_mid1 VDD VSS INV_S
X_buf2_WL0 WL0_mid1 WL0_mid2 VDD VSS INV_M
X_buf3_WL0 WL0_mid2 WL0 VDD VSS INV_L
X_nand4_WL1 clk_buf pre0_1 pre1_0 pre2_0 WL1_nand VDD VSS NAND4
X_buf1_WL1 WL1_nand WL1_mid1 VDD VSS INV_S
X_buf2_WL1 WL1_mid1 WL1_mid2 VDD VSS INV_M
X_buf3_WL1 WL1_mid2 WL1 VDD VSS INV_L
X_nand4_WL2 clk_buf pre0_2 pre1_0 pre2_0 WL2_nand VDD VSS NAND4
X_buf1_WL2 WL2_nand WL2_mid1 VDD VSS INV_S
X_buf2_WL2 WL2_mid1 WL2_mid2 VDD VSS INV_M
X_buf3_WL2 WL2_mid2 WL2 VDD VSS INV_L
X_nand4_WL3 clk_buf pre0_3 pre1_0 pre2_0 WL3_nand VDD VSS NAND4
X_buf1_WL3 WL3_nand WL3_mid1 VDD VSS INV_S
X_buf2_WL3 WL3_mid1 WL3_mid2 VDD VSS INV_M
X_buf3_WL3 WL3_mid2 WL3 VDD VSS INV_L
X_nand4_WL4 clk_buf pre0_0 pre1_1 pre2_0 WL4_nand VDD VSS NAND4
X_buf1_WL4 WL4_nand WL4_mid1 VDD VSS INV_S
X_buf2_WL4 WL4_mid1 WL4_mid2 VDD VSS INV_M
X_buf3_WL4 WL4_mid2 WL4 VDD VSS INV_L
X_nand4_WL5 clk_buf pre0_1 pre1_1 pre2_0 WL5_nand VDD VSS NAND4
X_buf1_WL5 WL5_nand WL5_mid1 VDD VSS INV_S
X_buf2_WL5 WL5_mid1 WL5_mid2 VDD VSS INV_M
X_buf3_WL5 WL5_mid2 WL5 VDD VSS INV_L
X_nand4_WL6 clk_buf pre0_2 pre1_1 pre2_0 WL6_nand VDD VSS NAND4
X_buf1_WL6 WL6_nand WL6_mid1 VDD VSS INV_S
X_buf2_WL6 WL6_mid1 WL6_mid2 VDD VSS INV_M
X_buf3_WL6 WL6_mid2 WL6 VDD VSS INV_L
X_nand4_WL7 clk_buf pre0_3 pre1_1 pre2_0 WL7_nand VDD VSS NAND4
X_buf1_WL7 WL7_nand WL7_mid1 VDD VSS INV_S
X_buf2_WL7 WL7_mid1 WL7_mid2 VDD VSS INV_M
X_buf3_WL7 WL7_mid2 WL7 VDD VSS INV_L
X_nand4_WL8 clk_buf pre0_0 pre1_2 pre2_0 WL8_nand VDD VSS NAND4
X_buf1_WL8 WL8_nand WL8_mid1 VDD VSS INV_S
X_buf2_WL8 WL8_mid1 WL8_mid2 VDD VSS INV_M
X_buf3_WL8 WL8_mid2 WL8 VDD VSS INV_L
X_nand4_WL9 clk_buf pre0_1 pre1_2 pre2_0 WL9_nand VDD VSS NAND4
X_buf1_WL9 WL9_nand WL9_mid1 VDD VSS INV_S
X_buf2_WL9 WL9_mid1 WL9_mid2 VDD VSS INV_M
X_buf3_WL9 WL9_mid2 WL9 VDD VSS INV_L
X_nand4_WL10 clk_buf pre0_2 pre1_2 pre2_0 WL10_nand VDD VSS NAND4
X_buf1_WL10 WL10_nand WL10_mid1 VDD VSS INV_S
X_buf2_WL10 WL10_mid1 WL10_mid2 VDD VSS INV_M
X_buf3_WL10 WL10_mid2 WL10 VDD VSS INV_L
X_nand4_WL11 clk_buf pre0_3 pre1_2 pre2_0 WL11_nand VDD VSS NAND4
X_buf1_WL11 WL11_nand WL11_mid1 VDD VSS INV_S
X_buf2_WL11 WL11_mid1 WL11_mid2 VDD VSS INV_M
X_buf3_WL11 WL11_mid2 WL11 VDD VSS INV_L
X_nand4_WL12 clk_buf pre0_0 pre1_3 pre2_0 WL12_nand VDD VSS NAND4
X_buf1_WL12 WL12_nand WL12_mid1 VDD VSS INV_S
X_buf2_WL12 WL12_mid1 WL12_mid2 VDD VSS INV_M
X_buf3_WL12 WL12_mid2 WL12 VDD VSS INV_L
X_nand4_WL13 clk_buf pre0_1 pre1_3 pre2_0 WL13_nand VDD VSS NAND4
X_buf1_WL13 WL13_nand WL13_mid1 VDD VSS INV_S
X_buf2_WL13 WL13_mid1 WL13_mid2 VDD VSS INV_M
X_buf3_WL13 WL13_mid2 WL13 VDD VSS INV_L
X_nand4_WL14 clk_buf pre0_2 pre1_3 pre2_0 WL14_nand VDD VSS NAND4
X_buf1_WL14 WL14_nand WL14_mid1 VDD VSS INV_S
X_buf2_WL14 WL14_mid1 WL14_mid2 VDD VSS INV_M
X_buf3_WL14 WL14_mid2 WL14 VDD VSS INV_L
X_nand4_WL15 clk_buf pre0_3 pre1_3 pre2_0 WL15_nand VDD VSS NAND4
X_buf1_WL15 WL15_nand WL15_mid1 VDD VSS INV_S
X_buf2_WL15 WL15_mid1 WL15_mid2 VDD VSS INV_M
X_buf3_WL15 WL15_mid2 WL15 VDD VSS INV_L
X_nand4_WL16 clk_buf pre0_0 pre1_0 pre2_1 WL16_nand VDD VSS NAND4
X_buf1_WL16 WL16_nand WL16_mid1 VDD VSS INV_S
X_buf2_WL16 WL16_mid1 WL16_mid2 VDD VSS INV_M
X_buf3_WL16 WL16_mid2 WL16 VDD VSS INV_L
X_nand4_WL17 clk_buf pre0_1 pre1_0 pre2_1 WL17_nand VDD VSS NAND4
X_buf1_WL17 WL17_nand WL17_mid1 VDD VSS INV_S
X_buf2_WL17 WL17_mid1 WL17_mid2 VDD VSS INV_M
X_buf3_WL17 WL17_mid2 WL17 VDD VSS INV_L
X_nand4_WL18 clk_buf pre0_2 pre1_0 pre2_1 WL18_nand VDD VSS NAND4
X_buf1_WL18 WL18_nand WL18_mid1 VDD VSS INV_S
X_buf2_WL18 WL18_mid1 WL18_mid2 VDD VSS INV_M
X_buf3_WL18 WL18_mid2 WL18 VDD VSS INV_L
X_nand4_WL19 clk_buf pre0_3 pre1_0 pre2_1 WL19_nand VDD VSS NAND4
X_buf1_WL19 WL19_nand WL19_mid1 VDD VSS INV_S
X_buf2_WL19 WL19_mid1 WL19_mid2 VDD VSS INV_M
X_buf3_WL19 WL19_mid2 WL19 VDD VSS INV_L
X_nand4_WL20 clk_buf pre0_0 pre1_1 pre2_1 WL20_nand VDD VSS NAND4
X_buf1_WL20 WL20_nand WL20_mid1 VDD VSS INV_S
X_buf2_WL20 WL20_mid1 WL20_mid2 VDD VSS INV_M
X_buf3_WL20 WL20_mid2 WL20 VDD VSS INV_L
X_nand4_WL21 clk_buf pre0_1 pre1_1 pre2_1 WL21_nand VDD VSS NAND4
X_buf1_WL21 WL21_nand WL21_mid1 VDD VSS INV_S
X_buf2_WL21 WL21_mid1 WL21_mid2 VDD VSS INV_M
X_buf3_WL21 WL21_mid2 WL21 VDD VSS INV_L
X_nand4_WL22 clk_buf pre0_2 pre1_1 pre2_1 WL22_nand VDD VSS NAND4
X_buf1_WL22 WL22_nand WL22_mid1 VDD VSS INV_S
X_buf2_WL22 WL22_mid1 WL22_mid2 VDD VSS INV_M
X_buf3_WL22 WL22_mid2 WL22 VDD VSS INV_L
X_nand4_WL23 clk_buf pre0_3 pre1_1 pre2_1 WL23_nand VDD VSS NAND4
X_buf1_WL23 WL23_nand WL23_mid1 VDD VSS INV_S
X_buf2_WL23 WL23_mid1 WL23_mid2 VDD VSS INV_M
X_buf3_WL23 WL23_mid2 WL23 VDD VSS INV_L
X_nand4_WL24 clk_buf pre0_0 pre1_2 pre2_1 WL24_nand VDD VSS NAND4
X_buf1_WL24 WL24_nand WL24_mid1 VDD VSS INV_S
X_buf2_WL24 WL24_mid1 WL24_mid2 VDD VSS INV_M
X_buf3_WL24 WL24_mid2 WL24 VDD VSS INV_L
X_nand4_WL25 clk_buf pre0_1 pre1_2 pre2_1 WL25_nand VDD VSS NAND4
X_buf1_WL25 WL25_nand WL25_mid1 VDD VSS INV_S
X_buf2_WL25 WL25_mid1 WL25_mid2 VDD VSS INV_M
X_buf3_WL25 WL25_mid2 WL25 VDD VSS INV_L
X_nand4_WL26 clk_buf pre0_2 pre1_2 pre2_1 WL26_nand VDD VSS NAND4
X_buf1_WL26 WL26_nand WL26_mid1 VDD VSS INV_S
X_buf2_WL26 WL26_mid1 WL26_mid2 VDD VSS INV_M
X_buf3_WL26 WL26_mid2 WL26 VDD VSS INV_L
X_nand4_WL27 clk_buf pre0_3 pre1_2 pre2_1 WL27_nand VDD VSS NAND4
X_buf1_WL27 WL27_nand WL27_mid1 VDD VSS INV_S
X_buf2_WL27 WL27_mid1 WL27_mid2 VDD VSS INV_M
X_buf3_WL27 WL27_mid2 WL27 VDD VSS INV_L
X_nand4_WL28 clk_buf pre0_0 pre1_3 pre2_1 WL28_nand VDD VSS NAND4
X_buf1_WL28 WL28_nand WL28_mid1 VDD VSS INV_S
X_buf2_WL28 WL28_mid1 WL28_mid2 VDD VSS INV_M
X_buf3_WL28 WL28_mid2 WL28 VDD VSS INV_L
X_nand4_WL29 clk_buf pre0_1 pre1_3 pre2_1 WL29_nand VDD VSS NAND4
X_buf1_WL29 WL29_nand WL29_mid1 VDD VSS INV_S
X_buf2_WL29 WL29_mid1 WL29_mid2 VDD VSS INV_M
X_buf3_WL29 WL29_mid2 WL29 VDD VSS INV_L
X_nand4_WL30 clk_buf pre0_2 pre1_3 pre2_1 WL30_nand VDD VSS NAND4
X_buf1_WL30 WL30_nand WL30_mid1 VDD VSS INV_S
X_buf2_WL30 WL30_mid1 WL30_mid2 VDD VSS INV_M
X_buf3_WL30 WL30_mid2 WL30 VDD VSS INV_L
X_nand4_WL31 clk_buf pre0_3 pre1_3 pre2_1 WL31_nand VDD VSS NAND4
X_buf1_WL31 WL31_nand WL31_mid1 VDD VSS INV_S
X_buf2_WL31 WL31_mid1 WL31_mid2 VDD VSS INV_M
X_buf3_WL31 WL31_mid2 WL31 VDD VSS INV_L
X_nand4_WL32 clk_buf pre0_0 pre1_0 pre2_2 WL32_nand VDD VSS NAND4
X_buf1_WL32 WL32_nand WL32_mid1 VDD VSS INV_S
X_buf2_WL32 WL32_mid1 WL32_mid2 VDD VSS INV_M
X_buf3_WL32 WL32_mid2 WL32 VDD VSS INV_L
X_nand4_WL33 clk_buf pre0_1 pre1_0 pre2_2 WL33_nand VDD VSS NAND4
X_buf1_WL33 WL33_nand WL33_mid1 VDD VSS INV_S
X_buf2_WL33 WL33_mid1 WL33_mid2 VDD VSS INV_M
X_buf3_WL33 WL33_mid2 WL33 VDD VSS INV_L
X_nand4_WL34 clk_buf pre0_2 pre1_0 pre2_2 WL34_nand VDD VSS NAND4
X_buf1_WL34 WL34_nand WL34_mid1 VDD VSS INV_S
X_buf2_WL34 WL34_mid1 WL34_mid2 VDD VSS INV_M
X_buf3_WL34 WL34_mid2 WL34 VDD VSS INV_L
X_nand4_WL35 clk_buf pre0_3 pre1_0 pre2_2 WL35_nand VDD VSS NAND4
X_buf1_WL35 WL35_nand WL35_mid1 VDD VSS INV_S
X_buf2_WL35 WL35_mid1 WL35_mid2 VDD VSS INV_M
X_buf3_WL35 WL35_mid2 WL35 VDD VSS INV_L
X_nand4_WL36 clk_buf pre0_0 pre1_1 pre2_2 WL36_nand VDD VSS NAND4
X_buf1_WL36 WL36_nand WL36_mid1 VDD VSS INV_S
X_buf2_WL36 WL36_mid1 WL36_mid2 VDD VSS INV_M
X_buf3_WL36 WL36_mid2 WL36 VDD VSS INV_L
X_nand4_WL37 clk_buf pre0_1 pre1_1 pre2_2 WL37_nand VDD VSS NAND4
X_buf1_WL37 WL37_nand WL37_mid1 VDD VSS INV_S
X_buf2_WL37 WL37_mid1 WL37_mid2 VDD VSS INV_M
X_buf3_WL37 WL37_mid2 WL37 VDD VSS INV_L
X_nand4_WL38 clk_buf pre0_2 pre1_1 pre2_2 WL38_nand VDD VSS NAND4
X_buf1_WL38 WL38_nand WL38_mid1 VDD VSS INV_S
X_buf2_WL38 WL38_mid1 WL38_mid2 VDD VSS INV_M
X_buf3_WL38 WL38_mid2 WL38 VDD VSS INV_L
X_nand4_WL39 clk_buf pre0_3 pre1_1 pre2_2 WL39_nand VDD VSS NAND4
X_buf1_WL39 WL39_nand WL39_mid1 VDD VSS INV_S
X_buf2_WL39 WL39_mid1 WL39_mid2 VDD VSS INV_M
X_buf3_WL39 WL39_mid2 WL39 VDD VSS INV_L
X_nand4_WL40 clk_buf pre0_0 pre1_2 pre2_2 WL40_nand VDD VSS NAND4
X_buf1_WL40 WL40_nand WL40_mid1 VDD VSS INV_S
X_buf2_WL40 WL40_mid1 WL40_mid2 VDD VSS INV_M
X_buf3_WL40 WL40_mid2 WL40 VDD VSS INV_L
X_nand4_WL41 clk_buf pre0_1 pre1_2 pre2_2 WL41_nand VDD VSS NAND4
X_buf1_WL41 WL41_nand WL41_mid1 VDD VSS INV_S
X_buf2_WL41 WL41_mid1 WL41_mid2 VDD VSS INV_M
X_buf3_WL41 WL41_mid2 WL41 VDD VSS INV_L
X_nand4_WL42 clk_buf pre0_2 pre1_2 pre2_2 WL42_nand VDD VSS NAND4
X_buf1_WL42 WL42_nand WL42_mid1 VDD VSS INV_S
X_buf2_WL42 WL42_mid1 WL42_mid2 VDD VSS INV_M
X_buf3_WL42 WL42_mid2 WL42 VDD VSS INV_L
X_nand4_WL43 clk_buf pre0_3 pre1_2 pre2_2 WL43_nand VDD VSS NAND4
X_buf1_WL43 WL43_nand WL43_mid1 VDD VSS INV_S
X_buf2_WL43 WL43_mid1 WL43_mid2 VDD VSS INV_M
X_buf3_WL43 WL43_mid2 WL43 VDD VSS INV_L
X_nand4_WL44 clk_buf pre0_0 pre1_3 pre2_2 WL44_nand VDD VSS NAND4
X_buf1_WL44 WL44_nand WL44_mid1 VDD VSS INV_S
X_buf2_WL44 WL44_mid1 WL44_mid2 VDD VSS INV_M
X_buf3_WL44 WL44_mid2 WL44 VDD VSS INV_L
X_nand4_WL45 clk_buf pre0_1 pre1_3 pre2_2 WL45_nand VDD VSS NAND4
X_buf1_WL45 WL45_nand WL45_mid1 VDD VSS INV_S
X_buf2_WL45 WL45_mid1 WL45_mid2 VDD VSS INV_M
X_buf3_WL45 WL45_mid2 WL45 VDD VSS INV_L
X_nand4_WL46 clk_buf pre0_2 pre1_3 pre2_2 WL46_nand VDD VSS NAND4
X_buf1_WL46 WL46_nand WL46_mid1 VDD VSS INV_S
X_buf2_WL46 WL46_mid1 WL46_mid2 VDD VSS INV_M
X_buf3_WL46 WL46_mid2 WL46 VDD VSS INV_L
X_nand4_WL47 clk_buf pre0_3 pre1_3 pre2_2 WL47_nand VDD VSS NAND4
X_buf1_WL47 WL47_nand WL47_mid1 VDD VSS INV_S
X_buf2_WL47 WL47_mid1 WL47_mid2 VDD VSS INV_M
X_buf3_WL47 WL47_mid2 WL47 VDD VSS INV_L
X_nand4_WL48 clk_buf pre0_0 pre1_0 pre2_3 WL48_nand VDD VSS NAND4
X_buf1_WL48 WL48_nand WL48_mid1 VDD VSS INV_S
X_buf2_WL48 WL48_mid1 WL48_mid2 VDD VSS INV_M
X_buf3_WL48 WL48_mid2 WL48 VDD VSS INV_L
X_nand4_WL49 clk_buf pre0_1 pre1_0 pre2_3 WL49_nand VDD VSS NAND4
X_buf1_WL49 WL49_nand WL49_mid1 VDD VSS INV_S
X_buf2_WL49 WL49_mid1 WL49_mid2 VDD VSS INV_M
X_buf3_WL49 WL49_mid2 WL49 VDD VSS INV_L
X_nand4_WL50 clk_buf pre0_2 pre1_0 pre2_3 WL50_nand VDD VSS NAND4
X_buf1_WL50 WL50_nand WL50_mid1 VDD VSS INV_S
X_buf2_WL50 WL50_mid1 WL50_mid2 VDD VSS INV_M
X_buf3_WL50 WL50_mid2 WL50 VDD VSS INV_L
X_nand4_WL51 clk_buf pre0_3 pre1_0 pre2_3 WL51_nand VDD VSS NAND4
X_buf1_WL51 WL51_nand WL51_mid1 VDD VSS INV_S
X_buf2_WL51 WL51_mid1 WL51_mid2 VDD VSS INV_M
X_buf3_WL51 WL51_mid2 WL51 VDD VSS INV_L
X_nand4_WL52 clk_buf pre0_0 pre1_1 pre2_3 WL52_nand VDD VSS NAND4
X_buf1_WL52 WL52_nand WL52_mid1 VDD VSS INV_S
X_buf2_WL52 WL52_mid1 WL52_mid2 VDD VSS INV_M
X_buf3_WL52 WL52_mid2 WL52 VDD VSS INV_L
X_nand4_WL53 clk_buf pre0_1 pre1_1 pre2_3 WL53_nand VDD VSS NAND4
X_buf1_WL53 WL53_nand WL53_mid1 VDD VSS INV_S
X_buf2_WL53 WL53_mid1 WL53_mid2 VDD VSS INV_M
X_buf3_WL53 WL53_mid2 WL53 VDD VSS INV_L
X_nand4_WL54 clk_buf pre0_2 pre1_1 pre2_3 WL54_nand VDD VSS NAND4
X_buf1_WL54 WL54_nand WL54_mid1 VDD VSS INV_S
X_buf2_WL54 WL54_mid1 WL54_mid2 VDD VSS INV_M
X_buf3_WL54 WL54_mid2 WL54 VDD VSS INV_L
X_nand4_WL55 clk_buf pre0_3 pre1_1 pre2_3 WL55_nand VDD VSS NAND4
X_buf1_WL55 WL55_nand WL55_mid1 VDD VSS INV_S
X_buf2_WL55 WL55_mid1 WL55_mid2 VDD VSS INV_M
X_buf3_WL55 WL55_mid2 WL55 VDD VSS INV_L
X_nand4_WL56 clk_buf pre0_0 pre1_2 pre2_3 WL56_nand VDD VSS NAND4
X_buf1_WL56 WL56_nand WL56_mid1 VDD VSS INV_S
X_buf2_WL56 WL56_mid1 WL56_mid2 VDD VSS INV_M
X_buf3_WL56 WL56_mid2 WL56 VDD VSS INV_L
X_nand4_WL57 clk_buf pre0_1 pre1_2 pre2_3 WL57_nand VDD VSS NAND4
X_buf1_WL57 WL57_nand WL57_mid1 VDD VSS INV_S
X_buf2_WL57 WL57_mid1 WL57_mid2 VDD VSS INV_M
X_buf3_WL57 WL57_mid2 WL57 VDD VSS INV_L
X_nand4_WL58 clk_buf pre0_2 pre1_2 pre2_3 WL58_nand VDD VSS NAND4
X_buf1_WL58 WL58_nand WL58_mid1 VDD VSS INV_S
X_buf2_WL58 WL58_mid1 WL58_mid2 VDD VSS INV_M
X_buf3_WL58 WL58_mid2 WL58 VDD VSS INV_L
X_nand4_WL59 clk_buf pre0_3 pre1_2 pre2_3 WL59_nand VDD VSS NAND4
X_buf1_WL59 WL59_nand WL59_mid1 VDD VSS INV_S
X_buf2_WL59 WL59_mid1 WL59_mid2 VDD VSS INV_M
X_buf3_WL59 WL59_mid2 WL59 VDD VSS INV_L
X_nand4_WL60 clk_buf pre0_0 pre1_3 pre2_3 WL60_nand VDD VSS NAND4
X_buf1_WL60 WL60_nand WL60_mid1 VDD VSS INV_S
X_buf2_WL60 WL60_mid1 WL60_mid2 VDD VSS INV_M
X_buf3_WL60 WL60_mid2 WL60 VDD VSS INV_L
X_nand4_WL61 clk_buf pre0_1 pre1_3 pre2_3 WL61_nand VDD VSS NAND4
X_buf1_WL61 WL61_nand WL61_mid1 VDD VSS INV_S
X_buf2_WL61 WL61_mid1 WL61_mid2 VDD VSS INV_M
X_buf3_WL61 WL61_mid2 WL61 VDD VSS INV_L
X_nand4_WL62 clk_buf pre0_2 pre1_3 pre2_3 WL62_nand VDD VSS NAND4
X_buf1_WL62 WL62_nand WL62_mid1 VDD VSS INV_S
X_buf2_WL62 WL62_mid1 WL62_mid2 VDD VSS INV_M
X_buf3_WL62 WL62_mid2 WL62 VDD VSS INV_L
X_nand4_WL63 clk_buf pre0_3 pre1_3 pre2_3 WL63_nand VDD VSS NAND4
X_buf1_WL63 WL63_nand WL63_mid1 VDD VSS INV_S
X_buf2_WL63 WL63_mid1 WL63_mid2 VDD VSS INV_M
X_buf3_WL63 WL63_mid2 WL63 VDD VSS INV_L
.ends
