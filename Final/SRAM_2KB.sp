* ======================================================================
* 2kb SRAM Pre-Simulation: Write and Read Operations Validation (Compact)
* Fixed: MUX tracking issue via removal of dummy load, restoring Ans functionality
* ======================================================================

.PROTECT
.INCLUDE '/RAID2/COURSE/2026_Spring/es26mcs/es26mcs068/7nm_TT.pm'
.UNPROTECT

.OPTION POST=1 FSDB
.OPTION RUNLVL=6
.OPTION METHOD=GEAR
.OPTION CAPTAB=1

.PARAM SUP = 0.7V
.GLOBAL VDD GND
VVDD VDD GND 'SUP'

* ======================================================================
* 1. 基礎邏輯與核心元件 (包含強健的 Buffer Tree)
* ======================================================================
* 最小 Buffer
.SUBCKT INV_MIN IN OUT
Mp OUT IN VDD VDD pmos_rvt nfin=2
Mn OUT IN GND GND nmos_rvt nfin=1
.ENDS
.SUBCKT BUF_MIN IN OUT
X1 IN N1 INV_MIN
X2 N1 OUT INV_MIN
.ENDS

* 驅動級 Buffer
.SUBCKT INV_X4 IN OUT
Mp OUT IN VDD VDD pmos_rvt nfin=8
Mn OUT IN GND GND nmos_rvt nfin=4
.ENDS
.SUBCKT BUF_X4 IN OUT
X1 IN N1 INV_X4
X2 N1 OUT INV_X4
.ENDS
.SUBCKT BUF_X16 IN OUT
X1 IN N1 BUF_X4
X2 N1 OUT BUF_X4
.ENDS
.SUBCKT BUF_X64 IN OUT
X1 IN N1 BUF_X16
X2 N1 OUT BUF_X16
.ENDS

* ======================================================================
* 2. Ans 子電路 (SRAM_CELL, MUX, SENSE_AMP, WRITE_DRIVER)
* ======================================================================
.subckt SRAM_CELL WL BL BLB VSS VDD
M_pl  q   qb  VDD VDD pmos_sram L=2e-08 W=2.7e-08 NFIN=1
M_nl  q   qb  VSS VSS nmos_sram L=2e-08 W=2.7e-08 NFIN=2
M_pr  qb  q   VDD VDD pmos_sram L=2e-08 W=2.7e-08 NFIN=1
M_nr  qb  q   VSS VSS nmos_sram L=2e-08 W=2.7e-08 NFIN=2
M_pgl BL  WL  q   VSS nmos_sram L=2e-08 W=2.7e-08 NFIN=2
M_pgr BLB WL  qb  VSS nmos_sram L=2e-08 W=2.7e-08 NFIN=2
.ends

.subckt PRECHARGE_UNIT PRE BL BLB VDD
M_pr1 BL  PRE VDD VDD pmos_sram L=2e-08 W=2.7e-08 NFIN=2
M_pr2 BLB PRE VDD VDD pmos_sram L=2e-08 W=2.7e-08 NFIN=2
M_pr3 BL  PRE BLB VDD pmos_sram L=2e-08 W=2.7e-08 NFIN=2
.ends

.subckt COL_MUX_2TO1 BL_in0 BLB_in0 BL_in1 BLB_in1 BL_out BLB_out sel0 sel1 VSS
M_mux0 BL_out  sel0 BL_in0  VSS nmos_sram L=2e-08 W=2.7e-08 NFIN=4
M_mux1 BLB_out sel0 BLB_in0 VSS nmos_sram L=2e-08 W=2.7e-08 NFIN=4
M_mux2 BL_out  sel1 BL_in1  VSS nmos_sram L=2e-08 W=2.7e-08 NFIN=4
M_mux3 BLB_out sel1 BLB_in1 VSS nmos_sram L=2e-08 W=2.7e-08 NFIN=4
.ends

.subckt SENSE_AMP_LATCH BL BLB sense sense_b SA_EN VDD VSS
M_pr_s1 sense   SA_EN VDD VDD pmos_sram L=2e-08 W=2.7e-08 NFIN=4
M_pr_s2 sense_b SA_EN VDD VDD pmos_sram L=2e-08 W=2.7e-08 NFIN=4
M_pr_eq sense   SA_EN sense_b VDD pmos_sram L=2e-08 W=2.7e-08 NFIN=4
M_pr_d1 di      SA_EN VDD VDD pmos_sram L=2e-08 W=2.7e-08 NFIN=4
M_pr_d2 dib     SA_EN VDD VDD pmos_sram L=2e-08 W=2.7e-08 NFIN=4
M_sa1 sense   sense_b VDD VDD pmos_sram L=2e-08 W=2.7e-08 NFIN=4
M_sa2 sense_b sense   VDD VDD pmos_sram L=2e-08 W=2.7e-08 NFIN=4
M_sa3 sense   sense_b di  VSS nmos_sram L=2e-08 W=2.7e-08 NFIN=4
M_sa4 sense_b sense   dib VSS nmos_sram L=2e-08 W=2.7e-08 NFIN=4
M_in1 di  BLB tail VSS nmos_sram L=2e-08 W=2.7e-08 NFIN=4
M_in2 dib BL  tail VSS nmos_sram L=2e-08 W=2.7e-08 NFIN=4
M_tail tail SA_EN VSS VSS nmos_sram L=2e-08 W=2.7e-08 NFIN=4
.ends

.subckt WRITE_DRIVER D D_bar WR_EN BL_out BLB_out VDD VSS
M_n1 BL_out WR_EN   D VSS nmos_sram L=2e-08 W=2.7e-08 NFIN=4
M_p1 BL_out WR_EN_b D VDD pmos_sram L=2e-08 W=2.7e-08 NFIN=4
M_n2 BLB_out WR_EN   D_bar VSS nmos_sram L=2e-08 W=2.7e-08 NFIN=4
M_p2 BLB_out WR_EN_b D_bar VDD pmos_sram L=2e-08 W=2.7e-08 NFIN=4
M_invp WR_EN_b WR_EN VDD VDD pmos_sram L=2e-08 W=2.7e-08 NFIN=2
M_invn WR_EN_b WR_EN VSS VSS nmos_sram L=2e-08 W=2.7e-08 NFIN=1
.ends

.subckt NAND2 A B Y VDD VSS
Mp1 Y A VDD VDD pmos_sram L=2e-08 W=2.7e-08 NFIN=2
Mp2 Y B VDD VDD pmos_sram L=2e-08 W=2.7e-08 NFIN=2
Mn1 Y A n1  VSS nmos_sram L=2e-08 W=2.7e-08 NFIN=2
Mn2 n1 B VSS VSS nmos_sram L=2e-08 W=2.7e-08 NFIN=2
.ends

.subckt INV_S in out VDD VSS
M_p out in VDD VDD pmos_sram L=2e-08 W=2.7e-08 NFIN=1
M_n out in VSS VSS nmos_sram L=2e-08 W=2.7e-08 NFIN=1
.ends
.subckt INV_M in out VDD VSS
M_p out in VDD VDD pmos_sram L=2e-08 W=2.7e-08 NFIN=2
M_n out in VSS VSS nmos_sram L=2e-08 W=2.7e-08 NFIN=2
.ends
.subckt INV_L in out VDD VSS
M_p out in VDD VDD pmos_sram L=2e-08 W=2.7e-08 NFIN=4
M_n out in VSS VSS nmos_sram L=2e-08 W=2.7e-08 NFIN=4
.ends

* ======================================================================
* 3. 架構封裝 (Compact ROW / COL_PERIPHERAL / GLOBAL_CTRL)
* ======================================================================

* 周邊控制邏輯：負責 Precharge, Mux, WD, SA
.SUBCKT COL_PERIPHERAL SEL0 SEL1 D_IN WEN CLK SAEN PRE BL0 BLB0 BL1 BLB1 Q_OUT
X_pre0 PRE BL0 BLB0 VDD PRECHARGE_UNIT
X_pre1 PRE BL1 BLB1 VDD PRECHARGE_UNIT
X_mux BL0 BLB0 BL1 BLB1 BL_CH BLB_CH SEL0 SEL1 GND COL_MUX_2TO1
X_wd_inv D_IN D_IN_B VDD GND INV_L
X_wd D_IN D_IN_B WEN BL_CH BLB_CH VDD GND WRITE_DRIVER
X_sa BL_CH BLB_CH sense sense_b SAEN VDD GND SENSE_AMP_LATCH
X_out_buf sense_b Q_OUT VDD GND INV_M
.ENDS

* 頂層核心時脈與讀寫控制
.SUBCKT GLOBAL_CTRL CLK WEN PRE WR_EN SAEN
X_pre_buf1 CLK clk_b VDD GND INV_S
X_pre_buf2 clk_b PRE VDD GND INV_L
X_wen_inv WEN WEN_b VDD GND INV_S
X_wr_nand CLK WEN_b WR_EN_nand VDD GND NAND2
X_wr_buf  WR_EN_nand WR_EN VDD GND INV_L
X_d1 CLK clk_d1 VDD GND INV_S
X_d2 clk_d1 clk_d2 VDD GND INV_S
X_d3 clk_d2 clk_d3 VDD GND INV_S
X_d4 clk_d3 clk_d4 VDD GND INV_S
X_d5 clk_d4 clk_d5 VDD GND INV_S
X_d6 clk_d5 clk_d6 VDD GND INV_S
X_d7 clk_d6 clk_d7 VDD GND INV_S
X_d8 clk_d7 clk_d8 VDD GND INV_S
X_d9 clk_d8 clk_d9 VDD GND INV_S
X_d10 clk_d9 clk_d10 VDD GND INV_S
X_d11 clk_d10 clk_d11 VDD GND INV_S
X_d12 clk_d11 clk_d12 VDD GND INV_S
X_d13 clk_d12 clk_d13 VDD GND INV_S
X_d14 clk_d13 clk_d14 VDD GND INV_S
X_d15 clk_d14 clk_d15 VDD GND INV_S
X_d16 clk_d15 clk_d16 VDD GND INV_S
X_d17 clk_d16 clk_d17 VDD GND INV_S
X_d18 clk_d17 clk_d18 VDD GND INV_S
X_d19 clk_d18 clk_d19 VDD GND INV_S
X_d20 clk_d19 clk_d20 VDD GND INV_S
X_d21 clk_d20 clk_d21 VDD GND INV_S
X_d22 clk_d21 clk_d22 VDD GND INV_S
X_d23 clk_d22 clk_d23 VDD GND INV_S
X_d24 clk_d23 clk_d24 VDD GND INV_S
X_d25 clk_d24 clk_d25 VDD GND INV_S
X_d26 clk_d25 clk_d26 VDD GND INV_S
X_d27 clk_d26 clk_d27 VDD GND INV_S
X_d28 clk_d27 clk_d28 VDD GND INV_S
X_d29 clk_d28 clk_d29 VDD GND INV_S
X_d30 clk_d29 clk_d30 VDD GND INV_S
X_d31 clk_d30 clk_d31 VDD GND INV_S
X_d32 clk_d31 clk_delayed VDD GND INV_S
X_sa_nand clk_delayed WEN SA_EN_nand VDD GND NAND2
X_sa_buf  SA_EN_nand SA_EN VDD GND INV_L
.ENDS

* ======================================================================
* 4. 系統核心整合 (Top Level Pre-Sim Structure)
* ======================================================================
X_CTRL CLK WEN PRE WR_EN SAEN GLOBAL_CTRL

X_a0_inv A0 A0_b VDD GND INV_S
X_sel0_buf A0 A0_sel0 VDD GND INV_L
X_sel1_buf A0_b A0_sel1 VDD GND INV_L

* 引入全新的 3 組 2-to-4 Decoder
.INCLUDE 'decoder_6to64_3x2to4.sp'

* 實體化 6-to-64 Row Decoder
X_ROW_DEC CLK A6 A5 A4 A3 A2 A1 WL0 WL1 WL2 WL3 WL4 WL5 WL6 WL7 WL8 WL9 WL10 WL11 WL12 WL13 WL14 WL15 WL16 WL17 WL18 WL19 WL20 WL21 WL22 WL23 WL24 WL25 WL26 WL27 WL28 WL29 WL30 WL31 WL32 WL33 WL34 WL35 WL36 WL37 WL38 WL39 WL40 WL41 WL42 WL43 WL44 WL45 WL46 WL47 WL48 WL49 WL50 WL51 WL52 WL53 WL54 WL55 WL56 WL57 WL58 WL59 WL60 WL61 WL62 WL63 VDD GND ROW_DECODER_3X2TO4

* 為了避免任何 HSPICE 陣列語法的解析問題，這裡直接展開所有的 64 列 x 32 行 (2048 顆 Cell)：
* Row 0
X_cell_0_0 WL0 BL[0] BLB[0] GND VDD SRAM_CELL
X_cell_0_1 WL0 BL[1] BLB[1] GND VDD SRAM_CELL
X_cell_0_2 WL0 BL[2] BLB[2] GND VDD SRAM_CELL
X_cell_0_3 WL0 BL[3] BLB[3] GND VDD SRAM_CELL
X_cell_0_4 WL0 BL[4] BLB[4] GND VDD SRAM_CELL
X_cell_0_5 WL0 BL[5] BLB[5] GND VDD SRAM_CELL
X_cell_0_6 WL0 BL[6] BLB[6] GND VDD SRAM_CELL
X_cell_0_7 WL0 BL[7] BLB[7] GND VDD SRAM_CELL
X_cell_0_8 WL0 BL[8] BLB[8] GND VDD SRAM_CELL
X_cell_0_9 WL0 BL[9] BLB[9] GND VDD SRAM_CELL
X_cell_0_10 WL0 BL[10] BLB[10] GND VDD SRAM_CELL
X_cell_0_11 WL0 BL[11] BLB[11] GND VDD SRAM_CELL
X_cell_0_12 WL0 BL[12] BLB[12] GND VDD SRAM_CELL
X_cell_0_13 WL0 BL[13] BLB[13] GND VDD SRAM_CELL
X_cell_0_14 WL0 BL[14] BLB[14] GND VDD SRAM_CELL
X_cell_0_15 WL0 BL[15] BLB[15] GND VDD SRAM_CELL
X_cell_0_16 WL0 BL[16] BLB[16] GND VDD SRAM_CELL
X_cell_0_17 WL0 BL[17] BLB[17] GND VDD SRAM_CELL
X_cell_0_18 WL0 BL[18] BLB[18] GND VDD SRAM_CELL
X_cell_0_19 WL0 BL[19] BLB[19] GND VDD SRAM_CELL
X_cell_0_20 WL0 BL[20] BLB[20] GND VDD SRAM_CELL
X_cell_0_21 WL0 BL[21] BLB[21] GND VDD SRAM_CELL
X_cell_0_22 WL0 BL[22] BLB[22] GND VDD SRAM_CELL
X_cell_0_23 WL0 BL[23] BLB[23] GND VDD SRAM_CELL
X_cell_0_24 WL0 BL[24] BLB[24] GND VDD SRAM_CELL
X_cell_0_25 WL0 BL[25] BLB[25] GND VDD SRAM_CELL
X_cell_0_26 WL0 BL[26] BLB[26] GND VDD SRAM_CELL
X_cell_0_27 WL0 BL[27] BLB[27] GND VDD SRAM_CELL
X_cell_0_28 WL0 BL[28] BLB[28] GND VDD SRAM_CELL
X_cell_0_29 WL0 BL[29] BLB[29] GND VDD SRAM_CELL
X_cell_0_30 WL0 BL[30] BLB[30] GND VDD SRAM_CELL
X_cell_0_31 WL0 BL[31] BLB[31] GND VDD SRAM_CELL
* Row 1
X_cell_1_0 WL1 BL[0] BLB[0] GND VDD SRAM_CELL
X_cell_1_1 WL1 BL[1] BLB[1] GND VDD SRAM_CELL
X_cell_1_2 WL1 BL[2] BLB[2] GND VDD SRAM_CELL
X_cell_1_3 WL1 BL[3] BLB[3] GND VDD SRAM_CELL
X_cell_1_4 WL1 BL[4] BLB[4] GND VDD SRAM_CELL
X_cell_1_5 WL1 BL[5] BLB[5] GND VDD SRAM_CELL
X_cell_1_6 WL1 BL[6] BLB[6] GND VDD SRAM_CELL
X_cell_1_7 WL1 BL[7] BLB[7] GND VDD SRAM_CELL
X_cell_1_8 WL1 BL[8] BLB[8] GND VDD SRAM_CELL
X_cell_1_9 WL1 BL[9] BLB[9] GND VDD SRAM_CELL
X_cell_1_10 WL1 BL[10] BLB[10] GND VDD SRAM_CELL
X_cell_1_11 WL1 BL[11] BLB[11] GND VDD SRAM_CELL
X_cell_1_12 WL1 BL[12] BLB[12] GND VDD SRAM_CELL
X_cell_1_13 WL1 BL[13] BLB[13] GND VDD SRAM_CELL
X_cell_1_14 WL1 BL[14] BLB[14] GND VDD SRAM_CELL
X_cell_1_15 WL1 BL[15] BLB[15] GND VDD SRAM_CELL
X_cell_1_16 WL1 BL[16] BLB[16] GND VDD SRAM_CELL
X_cell_1_17 WL1 BL[17] BLB[17] GND VDD SRAM_CELL
X_cell_1_18 WL1 BL[18] BLB[18] GND VDD SRAM_CELL
X_cell_1_19 WL1 BL[19] BLB[19] GND VDD SRAM_CELL
X_cell_1_20 WL1 BL[20] BLB[20] GND VDD SRAM_CELL
X_cell_1_21 WL1 BL[21] BLB[21] GND VDD SRAM_CELL
X_cell_1_22 WL1 BL[22] BLB[22] GND VDD SRAM_CELL
X_cell_1_23 WL1 BL[23] BLB[23] GND VDD SRAM_CELL
X_cell_1_24 WL1 BL[24] BLB[24] GND VDD SRAM_CELL
X_cell_1_25 WL1 BL[25] BLB[25] GND VDD SRAM_CELL
X_cell_1_26 WL1 BL[26] BLB[26] GND VDD SRAM_CELL
X_cell_1_27 WL1 BL[27] BLB[27] GND VDD SRAM_CELL
X_cell_1_28 WL1 BL[28] BLB[28] GND VDD SRAM_CELL
X_cell_1_29 WL1 BL[29] BLB[29] GND VDD SRAM_CELL
X_cell_1_30 WL1 BL[30] BLB[30] GND VDD SRAM_CELL
X_cell_1_31 WL1 BL[31] BLB[31] GND VDD SRAM_CELL
* Row 2
X_cell_2_0 WL2 BL[0] BLB[0] GND VDD SRAM_CELL
X_cell_2_1 WL2 BL[1] BLB[1] GND VDD SRAM_CELL
X_cell_2_2 WL2 BL[2] BLB[2] GND VDD SRAM_CELL
X_cell_2_3 WL2 BL[3] BLB[3] GND VDD SRAM_CELL
X_cell_2_4 WL2 BL[4] BLB[4] GND VDD SRAM_CELL
X_cell_2_5 WL2 BL[5] BLB[5] GND VDD SRAM_CELL
X_cell_2_6 WL2 BL[6] BLB[6] GND VDD SRAM_CELL
X_cell_2_7 WL2 BL[7] BLB[7] GND VDD SRAM_CELL
X_cell_2_8 WL2 BL[8] BLB[8] GND VDD SRAM_CELL
X_cell_2_9 WL2 BL[9] BLB[9] GND VDD SRAM_CELL
X_cell_2_10 WL2 BL[10] BLB[10] GND VDD SRAM_CELL
X_cell_2_11 WL2 BL[11] BLB[11] GND VDD SRAM_CELL
X_cell_2_12 WL2 BL[12] BLB[12] GND VDD SRAM_CELL
X_cell_2_13 WL2 BL[13] BLB[13] GND VDD SRAM_CELL
X_cell_2_14 WL2 BL[14] BLB[14] GND VDD SRAM_CELL
X_cell_2_15 WL2 BL[15] BLB[15] GND VDD SRAM_CELL
X_cell_2_16 WL2 BL[16] BLB[16] GND VDD SRAM_CELL
X_cell_2_17 WL2 BL[17] BLB[17] GND VDD SRAM_CELL
X_cell_2_18 WL2 BL[18] BLB[18] GND VDD SRAM_CELL
X_cell_2_19 WL2 BL[19] BLB[19] GND VDD SRAM_CELL
X_cell_2_20 WL2 BL[20] BLB[20] GND VDD SRAM_CELL
X_cell_2_21 WL2 BL[21] BLB[21] GND VDD SRAM_CELL
X_cell_2_22 WL2 BL[22] BLB[22] GND VDD SRAM_CELL
X_cell_2_23 WL2 BL[23] BLB[23] GND VDD SRAM_CELL
X_cell_2_24 WL2 BL[24] BLB[24] GND VDD SRAM_CELL
X_cell_2_25 WL2 BL[25] BLB[25] GND VDD SRAM_CELL
X_cell_2_26 WL2 BL[26] BLB[26] GND VDD SRAM_CELL
X_cell_2_27 WL2 BL[27] BLB[27] GND VDD SRAM_CELL
X_cell_2_28 WL2 BL[28] BLB[28] GND VDD SRAM_CELL
X_cell_2_29 WL2 BL[29] BLB[29] GND VDD SRAM_CELL
X_cell_2_30 WL2 BL[30] BLB[30] GND VDD SRAM_CELL
X_cell_2_31 WL2 BL[31] BLB[31] GND VDD SRAM_CELL
* Row 3
X_cell_3_0 WL3 BL[0] BLB[0] GND VDD SRAM_CELL
X_cell_3_1 WL3 BL[1] BLB[1] GND VDD SRAM_CELL
X_cell_3_2 WL3 BL[2] BLB[2] GND VDD SRAM_CELL
X_cell_3_3 WL3 BL[3] BLB[3] GND VDD SRAM_CELL
X_cell_3_4 WL3 BL[4] BLB[4] GND VDD SRAM_CELL
X_cell_3_5 WL3 BL[5] BLB[5] GND VDD SRAM_CELL
X_cell_3_6 WL3 BL[6] BLB[6] GND VDD SRAM_CELL
X_cell_3_7 WL3 BL[7] BLB[7] GND VDD SRAM_CELL
X_cell_3_8 WL3 BL[8] BLB[8] GND VDD SRAM_CELL
X_cell_3_9 WL3 BL[9] BLB[9] GND VDD SRAM_CELL
X_cell_3_10 WL3 BL[10] BLB[10] GND VDD SRAM_CELL
X_cell_3_11 WL3 BL[11] BLB[11] GND VDD SRAM_CELL
X_cell_3_12 WL3 BL[12] BLB[12] GND VDD SRAM_CELL
X_cell_3_13 WL3 BL[13] BLB[13] GND VDD SRAM_CELL
X_cell_3_14 WL3 BL[14] BLB[14] GND VDD SRAM_CELL
X_cell_3_15 WL3 BL[15] BLB[15] GND VDD SRAM_CELL
X_cell_3_16 WL3 BL[16] BLB[16] GND VDD SRAM_CELL
X_cell_3_17 WL3 BL[17] BLB[17] GND VDD SRAM_CELL
X_cell_3_18 WL3 BL[18] BLB[18] GND VDD SRAM_CELL
X_cell_3_19 WL3 BL[19] BLB[19] GND VDD SRAM_CELL
X_cell_3_20 WL3 BL[20] BLB[20] GND VDD SRAM_CELL
X_cell_3_21 WL3 BL[21] BLB[21] GND VDD SRAM_CELL
X_cell_3_22 WL3 BL[22] BLB[22] GND VDD SRAM_CELL
X_cell_3_23 WL3 BL[23] BLB[23] GND VDD SRAM_CELL
X_cell_3_24 WL3 BL[24] BLB[24] GND VDD SRAM_CELL
X_cell_3_25 WL3 BL[25] BLB[25] GND VDD SRAM_CELL
X_cell_3_26 WL3 BL[26] BLB[26] GND VDD SRAM_CELL
X_cell_3_27 WL3 BL[27] BLB[27] GND VDD SRAM_CELL
X_cell_3_28 WL3 BL[28] BLB[28] GND VDD SRAM_CELL
X_cell_3_29 WL3 BL[29] BLB[29] GND VDD SRAM_CELL
X_cell_3_30 WL3 BL[30] BLB[30] GND VDD SRAM_CELL
X_cell_3_31 WL3 BL[31] BLB[31] GND VDD SRAM_CELL
* Row 4
X_cell_4_0 WL4 BL[0] BLB[0] GND VDD SRAM_CELL
X_cell_4_1 WL4 BL[1] BLB[1] GND VDD SRAM_CELL
X_cell_4_2 WL4 BL[2] BLB[2] GND VDD SRAM_CELL
X_cell_4_3 WL4 BL[3] BLB[3] GND VDD SRAM_CELL
X_cell_4_4 WL4 BL[4] BLB[4] GND VDD SRAM_CELL
X_cell_4_5 WL4 BL[5] BLB[5] GND VDD SRAM_CELL
X_cell_4_6 WL4 BL[6] BLB[6] GND VDD SRAM_CELL
X_cell_4_7 WL4 BL[7] BLB[7] GND VDD SRAM_CELL
X_cell_4_8 WL4 BL[8] BLB[8] GND VDD SRAM_CELL
X_cell_4_9 WL4 BL[9] BLB[9] GND VDD SRAM_CELL
X_cell_4_10 WL4 BL[10] BLB[10] GND VDD SRAM_CELL
X_cell_4_11 WL4 BL[11] BLB[11] GND VDD SRAM_CELL
X_cell_4_12 WL4 BL[12] BLB[12] GND VDD SRAM_CELL
X_cell_4_13 WL4 BL[13] BLB[13] GND VDD SRAM_CELL
X_cell_4_14 WL4 BL[14] BLB[14] GND VDD SRAM_CELL
X_cell_4_15 WL4 BL[15] BLB[15] GND VDD SRAM_CELL
X_cell_4_16 WL4 BL[16] BLB[16] GND VDD SRAM_CELL
X_cell_4_17 WL4 BL[17] BLB[17] GND VDD SRAM_CELL
X_cell_4_18 WL4 BL[18] BLB[18] GND VDD SRAM_CELL
X_cell_4_19 WL4 BL[19] BLB[19] GND VDD SRAM_CELL
X_cell_4_20 WL4 BL[20] BLB[20] GND VDD SRAM_CELL
X_cell_4_21 WL4 BL[21] BLB[21] GND VDD SRAM_CELL
X_cell_4_22 WL4 BL[22] BLB[22] GND VDD SRAM_CELL
X_cell_4_23 WL4 BL[23] BLB[23] GND VDD SRAM_CELL
X_cell_4_24 WL4 BL[24] BLB[24] GND VDD SRAM_CELL
X_cell_4_25 WL4 BL[25] BLB[25] GND VDD SRAM_CELL
X_cell_4_26 WL4 BL[26] BLB[26] GND VDD SRAM_CELL
X_cell_4_27 WL4 BL[27] BLB[27] GND VDD SRAM_CELL
X_cell_4_28 WL4 BL[28] BLB[28] GND VDD SRAM_CELL
X_cell_4_29 WL4 BL[29] BLB[29] GND VDD SRAM_CELL
X_cell_4_30 WL4 BL[30] BLB[30] GND VDD SRAM_CELL
X_cell_4_31 WL4 BL[31] BLB[31] GND VDD SRAM_CELL
* Row 5
X_cell_5_0 WL5 BL[0] BLB[0] GND VDD SRAM_CELL
X_cell_5_1 WL5 BL[1] BLB[1] GND VDD SRAM_CELL
X_cell_5_2 WL5 BL[2] BLB[2] GND VDD SRAM_CELL
X_cell_5_3 WL5 BL[3] BLB[3] GND VDD SRAM_CELL
X_cell_5_4 WL5 BL[4] BLB[4] GND VDD SRAM_CELL
X_cell_5_5 WL5 BL[5] BLB[5] GND VDD SRAM_CELL
X_cell_5_6 WL5 BL[6] BLB[6] GND VDD SRAM_CELL
X_cell_5_7 WL5 BL[7] BLB[7] GND VDD SRAM_CELL
X_cell_5_8 WL5 BL[8] BLB[8] GND VDD SRAM_CELL
X_cell_5_9 WL5 BL[9] BLB[9] GND VDD SRAM_CELL
X_cell_5_10 WL5 BL[10] BLB[10] GND VDD SRAM_CELL
X_cell_5_11 WL5 BL[11] BLB[11] GND VDD SRAM_CELL
X_cell_5_12 WL5 BL[12] BLB[12] GND VDD SRAM_CELL
X_cell_5_13 WL5 BL[13] BLB[13] GND VDD SRAM_CELL
X_cell_5_14 WL5 BL[14] BLB[14] GND VDD SRAM_CELL
X_cell_5_15 WL5 BL[15] BLB[15] GND VDD SRAM_CELL
X_cell_5_16 WL5 BL[16] BLB[16] GND VDD SRAM_CELL
X_cell_5_17 WL5 BL[17] BLB[17] GND VDD SRAM_CELL
X_cell_5_18 WL5 BL[18] BLB[18] GND VDD SRAM_CELL
X_cell_5_19 WL5 BL[19] BLB[19] GND VDD SRAM_CELL
X_cell_5_20 WL5 BL[20] BLB[20] GND VDD SRAM_CELL
X_cell_5_21 WL5 BL[21] BLB[21] GND VDD SRAM_CELL
X_cell_5_22 WL5 BL[22] BLB[22] GND VDD SRAM_CELL
X_cell_5_23 WL5 BL[23] BLB[23] GND VDD SRAM_CELL
X_cell_5_24 WL5 BL[24] BLB[24] GND VDD SRAM_CELL
X_cell_5_25 WL5 BL[25] BLB[25] GND VDD SRAM_CELL
X_cell_5_26 WL5 BL[26] BLB[26] GND VDD SRAM_CELL
X_cell_5_27 WL5 BL[27] BLB[27] GND VDD SRAM_CELL
X_cell_5_28 WL5 BL[28] BLB[28] GND VDD SRAM_CELL
X_cell_5_29 WL5 BL[29] BLB[29] GND VDD SRAM_CELL
X_cell_5_30 WL5 BL[30] BLB[30] GND VDD SRAM_CELL
X_cell_5_31 WL5 BL[31] BLB[31] GND VDD SRAM_CELL
* Row 6
X_cell_6_0 WL6 BL[0] BLB[0] GND VDD SRAM_CELL
X_cell_6_1 WL6 BL[1] BLB[1] GND VDD SRAM_CELL
X_cell_6_2 WL6 BL[2] BLB[2] GND VDD SRAM_CELL
X_cell_6_3 WL6 BL[3] BLB[3] GND VDD SRAM_CELL
X_cell_6_4 WL6 BL[4] BLB[4] GND VDD SRAM_CELL
X_cell_6_5 WL6 BL[5] BLB[5] GND VDD SRAM_CELL
X_cell_6_6 WL6 BL[6] BLB[6] GND VDD SRAM_CELL
X_cell_6_7 WL6 BL[7] BLB[7] GND VDD SRAM_CELL
X_cell_6_8 WL6 BL[8] BLB[8] GND VDD SRAM_CELL
X_cell_6_9 WL6 BL[9] BLB[9] GND VDD SRAM_CELL
X_cell_6_10 WL6 BL[10] BLB[10] GND VDD SRAM_CELL
X_cell_6_11 WL6 BL[11] BLB[11] GND VDD SRAM_CELL
X_cell_6_12 WL6 BL[12] BLB[12] GND VDD SRAM_CELL
X_cell_6_13 WL6 BL[13] BLB[13] GND VDD SRAM_CELL
X_cell_6_14 WL6 BL[14] BLB[14] GND VDD SRAM_CELL
X_cell_6_15 WL6 BL[15] BLB[15] GND VDD SRAM_CELL
X_cell_6_16 WL6 BL[16] BLB[16] GND VDD SRAM_CELL
X_cell_6_17 WL6 BL[17] BLB[17] GND VDD SRAM_CELL
X_cell_6_18 WL6 BL[18] BLB[18] GND VDD SRAM_CELL
X_cell_6_19 WL6 BL[19] BLB[19] GND VDD SRAM_CELL
X_cell_6_20 WL6 BL[20] BLB[20] GND VDD SRAM_CELL
X_cell_6_21 WL6 BL[21] BLB[21] GND VDD SRAM_CELL
X_cell_6_22 WL6 BL[22] BLB[22] GND VDD SRAM_CELL
X_cell_6_23 WL6 BL[23] BLB[23] GND VDD SRAM_CELL
X_cell_6_24 WL6 BL[24] BLB[24] GND VDD SRAM_CELL
X_cell_6_25 WL6 BL[25] BLB[25] GND VDD SRAM_CELL
X_cell_6_26 WL6 BL[26] BLB[26] GND VDD SRAM_CELL
X_cell_6_27 WL6 BL[27] BLB[27] GND VDD SRAM_CELL
X_cell_6_28 WL6 BL[28] BLB[28] GND VDD SRAM_CELL
X_cell_6_29 WL6 BL[29] BLB[29] GND VDD SRAM_CELL
X_cell_6_30 WL6 BL[30] BLB[30] GND VDD SRAM_CELL
X_cell_6_31 WL6 BL[31] BLB[31] GND VDD SRAM_CELL
* Row 7
X_cell_7_0 WL7 BL[0] BLB[0] GND VDD SRAM_CELL
X_cell_7_1 WL7 BL[1] BLB[1] GND VDD SRAM_CELL
X_cell_7_2 WL7 BL[2] BLB[2] GND VDD SRAM_CELL
X_cell_7_3 WL7 BL[3] BLB[3] GND VDD SRAM_CELL
X_cell_7_4 WL7 BL[4] BLB[4] GND VDD SRAM_CELL
X_cell_7_5 WL7 BL[5] BLB[5] GND VDD SRAM_CELL
X_cell_7_6 WL7 BL[6] BLB[6] GND VDD SRAM_CELL
X_cell_7_7 WL7 BL[7] BLB[7] GND VDD SRAM_CELL
X_cell_7_8 WL7 BL[8] BLB[8] GND VDD SRAM_CELL
X_cell_7_9 WL7 BL[9] BLB[9] GND VDD SRAM_CELL
X_cell_7_10 WL7 BL[10] BLB[10] GND VDD SRAM_CELL
X_cell_7_11 WL7 BL[11] BLB[11] GND VDD SRAM_CELL
X_cell_7_12 WL7 BL[12] BLB[12] GND VDD SRAM_CELL
X_cell_7_13 WL7 BL[13] BLB[13] GND VDD SRAM_CELL
X_cell_7_14 WL7 BL[14] BLB[14] GND VDD SRAM_CELL
X_cell_7_15 WL7 BL[15] BLB[15] GND VDD SRAM_CELL
X_cell_7_16 WL7 BL[16] BLB[16] GND VDD SRAM_CELL
X_cell_7_17 WL7 BL[17] BLB[17] GND VDD SRAM_CELL
X_cell_7_18 WL7 BL[18] BLB[18] GND VDD SRAM_CELL
X_cell_7_19 WL7 BL[19] BLB[19] GND VDD SRAM_CELL
X_cell_7_20 WL7 BL[20] BLB[20] GND VDD SRAM_CELL
X_cell_7_21 WL7 BL[21] BLB[21] GND VDD SRAM_CELL
X_cell_7_22 WL7 BL[22] BLB[22] GND VDD SRAM_CELL
X_cell_7_23 WL7 BL[23] BLB[23] GND VDD SRAM_CELL
X_cell_7_24 WL7 BL[24] BLB[24] GND VDD SRAM_CELL
X_cell_7_25 WL7 BL[25] BLB[25] GND VDD SRAM_CELL
X_cell_7_26 WL7 BL[26] BLB[26] GND VDD SRAM_CELL
X_cell_7_27 WL7 BL[27] BLB[27] GND VDD SRAM_CELL
X_cell_7_28 WL7 BL[28] BLB[28] GND VDD SRAM_CELL
X_cell_7_29 WL7 BL[29] BLB[29] GND VDD SRAM_CELL
X_cell_7_30 WL7 BL[30] BLB[30] GND VDD SRAM_CELL
X_cell_7_31 WL7 BL[31] BLB[31] GND VDD SRAM_CELL
* Row 8
X_cell_8_0 WL8 BL[0] BLB[0] GND VDD SRAM_CELL
X_cell_8_1 WL8 BL[1] BLB[1] GND VDD SRAM_CELL
X_cell_8_2 WL8 BL[2] BLB[2] GND VDD SRAM_CELL
X_cell_8_3 WL8 BL[3] BLB[3] GND VDD SRAM_CELL
X_cell_8_4 WL8 BL[4] BLB[4] GND VDD SRAM_CELL
X_cell_8_5 WL8 BL[5] BLB[5] GND VDD SRAM_CELL
X_cell_8_6 WL8 BL[6] BLB[6] GND VDD SRAM_CELL
X_cell_8_7 WL8 BL[7] BLB[7] GND VDD SRAM_CELL
X_cell_8_8 WL8 BL[8] BLB[8] GND VDD SRAM_CELL
X_cell_8_9 WL8 BL[9] BLB[9] GND VDD SRAM_CELL
X_cell_8_10 WL8 BL[10] BLB[10] GND VDD SRAM_CELL
X_cell_8_11 WL8 BL[11] BLB[11] GND VDD SRAM_CELL
X_cell_8_12 WL8 BL[12] BLB[12] GND VDD SRAM_CELL
X_cell_8_13 WL8 BL[13] BLB[13] GND VDD SRAM_CELL
X_cell_8_14 WL8 BL[14] BLB[14] GND VDD SRAM_CELL
X_cell_8_15 WL8 BL[15] BLB[15] GND VDD SRAM_CELL
X_cell_8_16 WL8 BL[16] BLB[16] GND VDD SRAM_CELL
X_cell_8_17 WL8 BL[17] BLB[17] GND VDD SRAM_CELL
X_cell_8_18 WL8 BL[18] BLB[18] GND VDD SRAM_CELL
X_cell_8_19 WL8 BL[19] BLB[19] GND VDD SRAM_CELL
X_cell_8_20 WL8 BL[20] BLB[20] GND VDD SRAM_CELL
X_cell_8_21 WL8 BL[21] BLB[21] GND VDD SRAM_CELL
X_cell_8_22 WL8 BL[22] BLB[22] GND VDD SRAM_CELL
X_cell_8_23 WL8 BL[23] BLB[23] GND VDD SRAM_CELL
X_cell_8_24 WL8 BL[24] BLB[24] GND VDD SRAM_CELL
X_cell_8_25 WL8 BL[25] BLB[25] GND VDD SRAM_CELL
X_cell_8_26 WL8 BL[26] BLB[26] GND VDD SRAM_CELL
X_cell_8_27 WL8 BL[27] BLB[27] GND VDD SRAM_CELL
X_cell_8_28 WL8 BL[28] BLB[28] GND VDD SRAM_CELL
X_cell_8_29 WL8 BL[29] BLB[29] GND VDD SRAM_CELL
X_cell_8_30 WL8 BL[30] BLB[30] GND VDD SRAM_CELL
X_cell_8_31 WL8 BL[31] BLB[31] GND VDD SRAM_CELL
* Row 9
X_cell_9_0 WL9 BL[0] BLB[0] GND VDD SRAM_CELL
X_cell_9_1 WL9 BL[1] BLB[1] GND VDD SRAM_CELL
X_cell_9_2 WL9 BL[2] BLB[2] GND VDD SRAM_CELL
X_cell_9_3 WL9 BL[3] BLB[3] GND VDD SRAM_CELL
X_cell_9_4 WL9 BL[4] BLB[4] GND VDD SRAM_CELL
X_cell_9_5 WL9 BL[5] BLB[5] GND VDD SRAM_CELL
X_cell_9_6 WL9 BL[6] BLB[6] GND VDD SRAM_CELL
X_cell_9_7 WL9 BL[7] BLB[7] GND VDD SRAM_CELL
X_cell_9_8 WL9 BL[8] BLB[8] GND VDD SRAM_CELL
X_cell_9_9 WL9 BL[9] BLB[9] GND VDD SRAM_CELL
X_cell_9_10 WL9 BL[10] BLB[10] GND VDD SRAM_CELL
X_cell_9_11 WL9 BL[11] BLB[11] GND VDD SRAM_CELL
X_cell_9_12 WL9 BL[12] BLB[12] GND VDD SRAM_CELL
X_cell_9_13 WL9 BL[13] BLB[13] GND VDD SRAM_CELL
X_cell_9_14 WL9 BL[14] BLB[14] GND VDD SRAM_CELL
X_cell_9_15 WL9 BL[15] BLB[15] GND VDD SRAM_CELL
X_cell_9_16 WL9 BL[16] BLB[16] GND VDD SRAM_CELL
X_cell_9_17 WL9 BL[17] BLB[17] GND VDD SRAM_CELL
X_cell_9_18 WL9 BL[18] BLB[18] GND VDD SRAM_CELL
X_cell_9_19 WL9 BL[19] BLB[19] GND VDD SRAM_CELL
X_cell_9_20 WL9 BL[20] BLB[20] GND VDD SRAM_CELL
X_cell_9_21 WL9 BL[21] BLB[21] GND VDD SRAM_CELL
X_cell_9_22 WL9 BL[22] BLB[22] GND VDD SRAM_CELL
X_cell_9_23 WL9 BL[23] BLB[23] GND VDD SRAM_CELL
X_cell_9_24 WL9 BL[24] BLB[24] GND VDD SRAM_CELL
X_cell_9_25 WL9 BL[25] BLB[25] GND VDD SRAM_CELL
X_cell_9_26 WL9 BL[26] BLB[26] GND VDD SRAM_CELL
X_cell_9_27 WL9 BL[27] BLB[27] GND VDD SRAM_CELL
X_cell_9_28 WL9 BL[28] BLB[28] GND VDD SRAM_CELL
X_cell_9_29 WL9 BL[29] BLB[29] GND VDD SRAM_CELL
X_cell_9_30 WL9 BL[30] BLB[30] GND VDD SRAM_CELL
X_cell_9_31 WL9 BL[31] BLB[31] GND VDD SRAM_CELL
* Row 10
X_cell_10_0 WL10 BL[0] BLB[0] GND VDD SRAM_CELL
X_cell_10_1 WL10 BL[1] BLB[1] GND VDD SRAM_CELL
X_cell_10_2 WL10 BL[2] BLB[2] GND VDD SRAM_CELL
X_cell_10_3 WL10 BL[3] BLB[3] GND VDD SRAM_CELL
X_cell_10_4 WL10 BL[4] BLB[4] GND VDD SRAM_CELL
X_cell_10_5 WL10 BL[5] BLB[5] GND VDD SRAM_CELL
X_cell_10_6 WL10 BL[6] BLB[6] GND VDD SRAM_CELL
X_cell_10_7 WL10 BL[7] BLB[7] GND VDD SRAM_CELL
X_cell_10_8 WL10 BL[8] BLB[8] GND VDD SRAM_CELL
X_cell_10_9 WL10 BL[9] BLB[9] GND VDD SRAM_CELL
X_cell_10_10 WL10 BL[10] BLB[10] GND VDD SRAM_CELL
X_cell_10_11 WL10 BL[11] BLB[11] GND VDD SRAM_CELL
X_cell_10_12 WL10 BL[12] BLB[12] GND VDD SRAM_CELL
X_cell_10_13 WL10 BL[13] BLB[13] GND VDD SRAM_CELL
X_cell_10_14 WL10 BL[14] BLB[14] GND VDD SRAM_CELL
X_cell_10_15 WL10 BL[15] BLB[15] GND VDD SRAM_CELL
X_cell_10_16 WL10 BL[16] BLB[16] GND VDD SRAM_CELL
X_cell_10_17 WL10 BL[17] BLB[17] GND VDD SRAM_CELL
X_cell_10_18 WL10 BL[18] BLB[18] GND VDD SRAM_CELL
X_cell_10_19 WL10 BL[19] BLB[19] GND VDD SRAM_CELL
X_cell_10_20 WL10 BL[20] BLB[20] GND VDD SRAM_CELL
X_cell_10_21 WL10 BL[21] BLB[21] GND VDD SRAM_CELL
X_cell_10_22 WL10 BL[22] BLB[22] GND VDD SRAM_CELL
X_cell_10_23 WL10 BL[23] BLB[23] GND VDD SRAM_CELL
X_cell_10_24 WL10 BL[24] BLB[24] GND VDD SRAM_CELL
X_cell_10_25 WL10 BL[25] BLB[25] GND VDD SRAM_CELL
X_cell_10_26 WL10 BL[26] BLB[26] GND VDD SRAM_CELL
X_cell_10_27 WL10 BL[27] BLB[27] GND VDD SRAM_CELL
X_cell_10_28 WL10 BL[28] BLB[28] GND VDD SRAM_CELL
X_cell_10_29 WL10 BL[29] BLB[29] GND VDD SRAM_CELL
X_cell_10_30 WL10 BL[30] BLB[30] GND VDD SRAM_CELL
X_cell_10_31 WL10 BL[31] BLB[31] GND VDD SRAM_CELL
* Row 11
X_cell_11_0 WL11 BL[0] BLB[0] GND VDD SRAM_CELL
X_cell_11_1 WL11 BL[1] BLB[1] GND VDD SRAM_CELL
X_cell_11_2 WL11 BL[2] BLB[2] GND VDD SRAM_CELL
X_cell_11_3 WL11 BL[3] BLB[3] GND VDD SRAM_CELL
X_cell_11_4 WL11 BL[4] BLB[4] GND VDD SRAM_CELL
X_cell_11_5 WL11 BL[5] BLB[5] GND VDD SRAM_CELL
X_cell_11_6 WL11 BL[6] BLB[6] GND VDD SRAM_CELL
X_cell_11_7 WL11 BL[7] BLB[7] GND VDD SRAM_CELL
X_cell_11_8 WL11 BL[8] BLB[8] GND VDD SRAM_CELL
X_cell_11_9 WL11 BL[9] BLB[9] GND VDD SRAM_CELL
X_cell_11_10 WL11 BL[10] BLB[10] GND VDD SRAM_CELL
X_cell_11_11 WL11 BL[11] BLB[11] GND VDD SRAM_CELL
X_cell_11_12 WL11 BL[12] BLB[12] GND VDD SRAM_CELL
X_cell_11_13 WL11 BL[13] BLB[13] GND VDD SRAM_CELL
X_cell_11_14 WL11 BL[14] BLB[14] GND VDD SRAM_CELL
X_cell_11_15 WL11 BL[15] BLB[15] GND VDD SRAM_CELL
X_cell_11_16 WL11 BL[16] BLB[16] GND VDD SRAM_CELL
X_cell_11_17 WL11 BL[17] BLB[17] GND VDD SRAM_CELL
X_cell_11_18 WL11 BL[18] BLB[18] GND VDD SRAM_CELL
X_cell_11_19 WL11 BL[19] BLB[19] GND VDD SRAM_CELL
X_cell_11_20 WL11 BL[20] BLB[20] GND VDD SRAM_CELL
X_cell_11_21 WL11 BL[21] BLB[21] GND VDD SRAM_CELL
X_cell_11_22 WL11 BL[22] BLB[22] GND VDD SRAM_CELL
X_cell_11_23 WL11 BL[23] BLB[23] GND VDD SRAM_CELL
X_cell_11_24 WL11 BL[24] BLB[24] GND VDD SRAM_CELL
X_cell_11_25 WL11 BL[25] BLB[25] GND VDD SRAM_CELL
X_cell_11_26 WL11 BL[26] BLB[26] GND VDD SRAM_CELL
X_cell_11_27 WL11 BL[27] BLB[27] GND VDD SRAM_CELL
X_cell_11_28 WL11 BL[28] BLB[28] GND VDD SRAM_CELL
X_cell_11_29 WL11 BL[29] BLB[29] GND VDD SRAM_CELL
X_cell_11_30 WL11 BL[30] BLB[30] GND VDD SRAM_CELL
X_cell_11_31 WL11 BL[31] BLB[31] GND VDD SRAM_CELL
* Row 12
X_cell_12_0 WL12 BL[0] BLB[0] GND VDD SRAM_CELL
X_cell_12_1 WL12 BL[1] BLB[1] GND VDD SRAM_CELL
X_cell_12_2 WL12 BL[2] BLB[2] GND VDD SRAM_CELL
X_cell_12_3 WL12 BL[3] BLB[3] GND VDD SRAM_CELL
X_cell_12_4 WL12 BL[4] BLB[4] GND VDD SRAM_CELL
X_cell_12_5 WL12 BL[5] BLB[5] GND VDD SRAM_CELL
X_cell_12_6 WL12 BL[6] BLB[6] GND VDD SRAM_CELL
X_cell_12_7 WL12 BL[7] BLB[7] GND VDD SRAM_CELL
X_cell_12_8 WL12 BL[8] BLB[8] GND VDD SRAM_CELL
X_cell_12_9 WL12 BL[9] BLB[9] GND VDD SRAM_CELL
X_cell_12_10 WL12 BL[10] BLB[10] GND VDD SRAM_CELL
X_cell_12_11 WL12 BL[11] BLB[11] GND VDD SRAM_CELL
X_cell_12_12 WL12 BL[12] BLB[12] GND VDD SRAM_CELL
X_cell_12_13 WL12 BL[13] BLB[13] GND VDD SRAM_CELL
X_cell_12_14 WL12 BL[14] BLB[14] GND VDD SRAM_CELL
X_cell_12_15 WL12 BL[15] BLB[15] GND VDD SRAM_CELL
X_cell_12_16 WL12 BL[16] BLB[16] GND VDD SRAM_CELL
X_cell_12_17 WL12 BL[17] BLB[17] GND VDD SRAM_CELL
X_cell_12_18 WL12 BL[18] BLB[18] GND VDD SRAM_CELL
X_cell_12_19 WL12 BL[19] BLB[19] GND VDD SRAM_CELL
X_cell_12_20 WL12 BL[20] BLB[20] GND VDD SRAM_CELL
X_cell_12_21 WL12 BL[21] BLB[21] GND VDD SRAM_CELL
X_cell_12_22 WL12 BL[22] BLB[22] GND VDD SRAM_CELL
X_cell_12_23 WL12 BL[23] BLB[23] GND VDD SRAM_CELL
X_cell_12_24 WL12 BL[24] BLB[24] GND VDD SRAM_CELL
X_cell_12_25 WL12 BL[25] BLB[25] GND VDD SRAM_CELL
X_cell_12_26 WL12 BL[26] BLB[26] GND VDD SRAM_CELL
X_cell_12_27 WL12 BL[27] BLB[27] GND VDD SRAM_CELL
X_cell_12_28 WL12 BL[28] BLB[28] GND VDD SRAM_CELL
X_cell_12_29 WL12 BL[29] BLB[29] GND VDD SRAM_CELL
X_cell_12_30 WL12 BL[30] BLB[30] GND VDD SRAM_CELL
X_cell_12_31 WL12 BL[31] BLB[31] GND VDD SRAM_CELL
* Row 13
X_cell_13_0 WL13 BL[0] BLB[0] GND VDD SRAM_CELL
X_cell_13_1 WL13 BL[1] BLB[1] GND VDD SRAM_CELL
X_cell_13_2 WL13 BL[2] BLB[2] GND VDD SRAM_CELL
X_cell_13_3 WL13 BL[3] BLB[3] GND VDD SRAM_CELL
X_cell_13_4 WL13 BL[4] BLB[4] GND VDD SRAM_CELL
X_cell_13_5 WL13 BL[5] BLB[5] GND VDD SRAM_CELL
X_cell_13_6 WL13 BL[6] BLB[6] GND VDD SRAM_CELL
X_cell_13_7 WL13 BL[7] BLB[7] GND VDD SRAM_CELL
X_cell_13_8 WL13 BL[8] BLB[8] GND VDD SRAM_CELL
X_cell_13_9 WL13 BL[9] BLB[9] GND VDD SRAM_CELL
X_cell_13_10 WL13 BL[10] BLB[10] GND VDD SRAM_CELL
X_cell_13_11 WL13 BL[11] BLB[11] GND VDD SRAM_CELL
X_cell_13_12 WL13 BL[12] BLB[12] GND VDD SRAM_CELL
X_cell_13_13 WL13 BL[13] BLB[13] GND VDD SRAM_CELL
X_cell_13_14 WL13 BL[14] BLB[14] GND VDD SRAM_CELL
X_cell_13_15 WL13 BL[15] BLB[15] GND VDD SRAM_CELL
X_cell_13_16 WL13 BL[16] BLB[16] GND VDD SRAM_CELL
X_cell_13_17 WL13 BL[17] BLB[17] GND VDD SRAM_CELL
X_cell_13_18 WL13 BL[18] BLB[18] GND VDD SRAM_CELL
X_cell_13_19 WL13 BL[19] BLB[19] GND VDD SRAM_CELL
X_cell_13_20 WL13 BL[20] BLB[20] GND VDD SRAM_CELL
X_cell_13_21 WL13 BL[21] BLB[21] GND VDD SRAM_CELL
X_cell_13_22 WL13 BL[22] BLB[22] GND VDD SRAM_CELL
X_cell_13_23 WL13 BL[23] BLB[23] GND VDD SRAM_CELL
X_cell_13_24 WL13 BL[24] BLB[24] GND VDD SRAM_CELL
X_cell_13_25 WL13 BL[25] BLB[25] GND VDD SRAM_CELL
X_cell_13_26 WL13 BL[26] BLB[26] GND VDD SRAM_CELL
X_cell_13_27 WL13 BL[27] BLB[27] GND VDD SRAM_CELL
X_cell_13_28 WL13 BL[28] BLB[28] GND VDD SRAM_CELL
X_cell_13_29 WL13 BL[29] BLB[29] GND VDD SRAM_CELL
X_cell_13_30 WL13 BL[30] BLB[30] GND VDD SRAM_CELL
X_cell_13_31 WL13 BL[31] BLB[31] GND VDD SRAM_CELL
* Row 14
X_cell_14_0 WL14 BL[0] BLB[0] GND VDD SRAM_CELL
X_cell_14_1 WL14 BL[1] BLB[1] GND VDD SRAM_CELL
X_cell_14_2 WL14 BL[2] BLB[2] GND VDD SRAM_CELL
X_cell_14_3 WL14 BL[3] BLB[3] GND VDD SRAM_CELL
X_cell_14_4 WL14 BL[4] BLB[4] GND VDD SRAM_CELL
X_cell_14_5 WL14 BL[5] BLB[5] GND VDD SRAM_CELL
X_cell_14_6 WL14 BL[6] BLB[6] GND VDD SRAM_CELL
X_cell_14_7 WL14 BL[7] BLB[7] GND VDD SRAM_CELL
X_cell_14_8 WL14 BL[8] BLB[8] GND VDD SRAM_CELL
X_cell_14_9 WL14 BL[9] BLB[9] GND VDD SRAM_CELL
X_cell_14_10 WL14 BL[10] BLB[10] GND VDD SRAM_CELL
X_cell_14_11 WL14 BL[11] BLB[11] GND VDD SRAM_CELL
X_cell_14_12 WL14 BL[12] BLB[12] GND VDD SRAM_CELL
X_cell_14_13 WL14 BL[13] BLB[13] GND VDD SRAM_CELL
X_cell_14_14 WL14 BL[14] BLB[14] GND VDD SRAM_CELL
X_cell_14_15 WL14 BL[15] BLB[15] GND VDD SRAM_CELL
X_cell_14_16 WL14 BL[16] BLB[16] GND VDD SRAM_CELL
X_cell_14_17 WL14 BL[17] BLB[17] GND VDD SRAM_CELL
X_cell_14_18 WL14 BL[18] BLB[18] GND VDD SRAM_CELL
X_cell_14_19 WL14 BL[19] BLB[19] GND VDD SRAM_CELL
X_cell_14_20 WL14 BL[20] BLB[20] GND VDD SRAM_CELL
X_cell_14_21 WL14 BL[21] BLB[21] GND VDD SRAM_CELL
X_cell_14_22 WL14 BL[22] BLB[22] GND VDD SRAM_CELL
X_cell_14_23 WL14 BL[23] BLB[23] GND VDD SRAM_CELL
X_cell_14_24 WL14 BL[24] BLB[24] GND VDD SRAM_CELL
X_cell_14_25 WL14 BL[25] BLB[25] GND VDD SRAM_CELL
X_cell_14_26 WL14 BL[26] BLB[26] GND VDD SRAM_CELL
X_cell_14_27 WL14 BL[27] BLB[27] GND VDD SRAM_CELL
X_cell_14_28 WL14 BL[28] BLB[28] GND VDD SRAM_CELL
X_cell_14_29 WL14 BL[29] BLB[29] GND VDD SRAM_CELL
X_cell_14_30 WL14 BL[30] BLB[30] GND VDD SRAM_CELL
X_cell_14_31 WL14 BL[31] BLB[31] GND VDD SRAM_CELL
* Row 15
X_cell_15_0 WL15 BL[0] BLB[0] GND VDD SRAM_CELL
X_cell_15_1 WL15 BL[1] BLB[1] GND VDD SRAM_CELL
X_cell_15_2 WL15 BL[2] BLB[2] GND VDD SRAM_CELL
X_cell_15_3 WL15 BL[3] BLB[3] GND VDD SRAM_CELL
X_cell_15_4 WL15 BL[4] BLB[4] GND VDD SRAM_CELL
X_cell_15_5 WL15 BL[5] BLB[5] GND VDD SRAM_CELL
X_cell_15_6 WL15 BL[6] BLB[6] GND VDD SRAM_CELL
X_cell_15_7 WL15 BL[7] BLB[7] GND VDD SRAM_CELL
X_cell_15_8 WL15 BL[8] BLB[8] GND VDD SRAM_CELL
X_cell_15_9 WL15 BL[9] BLB[9] GND VDD SRAM_CELL
X_cell_15_10 WL15 BL[10] BLB[10] GND VDD SRAM_CELL
X_cell_15_11 WL15 BL[11] BLB[11] GND VDD SRAM_CELL
X_cell_15_12 WL15 BL[12] BLB[12] GND VDD SRAM_CELL
X_cell_15_13 WL15 BL[13] BLB[13] GND VDD SRAM_CELL
X_cell_15_14 WL15 BL[14] BLB[14] GND VDD SRAM_CELL
X_cell_15_15 WL15 BL[15] BLB[15] GND VDD SRAM_CELL
X_cell_15_16 WL15 BL[16] BLB[16] GND VDD SRAM_CELL
X_cell_15_17 WL15 BL[17] BLB[17] GND VDD SRAM_CELL
X_cell_15_18 WL15 BL[18] BLB[18] GND VDD SRAM_CELL
X_cell_15_19 WL15 BL[19] BLB[19] GND VDD SRAM_CELL
X_cell_15_20 WL15 BL[20] BLB[20] GND VDD SRAM_CELL
X_cell_15_21 WL15 BL[21] BLB[21] GND VDD SRAM_CELL
X_cell_15_22 WL15 BL[22] BLB[22] GND VDD SRAM_CELL
X_cell_15_23 WL15 BL[23] BLB[23] GND VDD SRAM_CELL
X_cell_15_24 WL15 BL[24] BLB[24] GND VDD SRAM_CELL
X_cell_15_25 WL15 BL[25] BLB[25] GND VDD SRAM_CELL
X_cell_15_26 WL15 BL[26] BLB[26] GND VDD SRAM_CELL
X_cell_15_27 WL15 BL[27] BLB[27] GND VDD SRAM_CELL
X_cell_15_28 WL15 BL[28] BLB[28] GND VDD SRAM_CELL
X_cell_15_29 WL15 BL[29] BLB[29] GND VDD SRAM_CELL
X_cell_15_30 WL15 BL[30] BLB[30] GND VDD SRAM_CELL
X_cell_15_31 WL15 BL[31] BLB[31] GND VDD SRAM_CELL
* Row 16
X_cell_16_0 WL16 BL[0] BLB[0] GND VDD SRAM_CELL
X_cell_16_1 WL16 BL[1] BLB[1] GND VDD SRAM_CELL
X_cell_16_2 WL16 BL[2] BLB[2] GND VDD SRAM_CELL
X_cell_16_3 WL16 BL[3] BLB[3] GND VDD SRAM_CELL
X_cell_16_4 WL16 BL[4] BLB[4] GND VDD SRAM_CELL
X_cell_16_5 WL16 BL[5] BLB[5] GND VDD SRAM_CELL
X_cell_16_6 WL16 BL[6] BLB[6] GND VDD SRAM_CELL
X_cell_16_7 WL16 BL[7] BLB[7] GND VDD SRAM_CELL
X_cell_16_8 WL16 BL[8] BLB[8] GND VDD SRAM_CELL
X_cell_16_9 WL16 BL[9] BLB[9] GND VDD SRAM_CELL
X_cell_16_10 WL16 BL[10] BLB[10] GND VDD SRAM_CELL
X_cell_16_11 WL16 BL[11] BLB[11] GND VDD SRAM_CELL
X_cell_16_12 WL16 BL[12] BLB[12] GND VDD SRAM_CELL
X_cell_16_13 WL16 BL[13] BLB[13] GND VDD SRAM_CELL
X_cell_16_14 WL16 BL[14] BLB[14] GND VDD SRAM_CELL
X_cell_16_15 WL16 BL[15] BLB[15] GND VDD SRAM_CELL
X_cell_16_16 WL16 BL[16] BLB[16] GND VDD SRAM_CELL
X_cell_16_17 WL16 BL[17] BLB[17] GND VDD SRAM_CELL
X_cell_16_18 WL16 BL[18] BLB[18] GND VDD SRAM_CELL
X_cell_16_19 WL16 BL[19] BLB[19] GND VDD SRAM_CELL
X_cell_16_20 WL16 BL[20] BLB[20] GND VDD SRAM_CELL
X_cell_16_21 WL16 BL[21] BLB[21] GND VDD SRAM_CELL
X_cell_16_22 WL16 BL[22] BLB[22] GND VDD SRAM_CELL
X_cell_16_23 WL16 BL[23] BLB[23] GND VDD SRAM_CELL
X_cell_16_24 WL16 BL[24] BLB[24] GND VDD SRAM_CELL
X_cell_16_25 WL16 BL[25] BLB[25] GND VDD SRAM_CELL
X_cell_16_26 WL16 BL[26] BLB[26] GND VDD SRAM_CELL
X_cell_16_27 WL16 BL[27] BLB[27] GND VDD SRAM_CELL
X_cell_16_28 WL16 BL[28] BLB[28] GND VDD SRAM_CELL
X_cell_16_29 WL16 BL[29] BLB[29] GND VDD SRAM_CELL
X_cell_16_30 WL16 BL[30] BLB[30] GND VDD SRAM_CELL
X_cell_16_31 WL16 BL[31] BLB[31] GND VDD SRAM_CELL
* Row 17
X_cell_17_0 WL17 BL[0] BLB[0] GND VDD SRAM_CELL
X_cell_17_1 WL17 BL[1] BLB[1] GND VDD SRAM_CELL
X_cell_17_2 WL17 BL[2] BLB[2] GND VDD SRAM_CELL
X_cell_17_3 WL17 BL[3] BLB[3] GND VDD SRAM_CELL
X_cell_17_4 WL17 BL[4] BLB[4] GND VDD SRAM_CELL
X_cell_17_5 WL17 BL[5] BLB[5] GND VDD SRAM_CELL
X_cell_17_6 WL17 BL[6] BLB[6] GND VDD SRAM_CELL
X_cell_17_7 WL17 BL[7] BLB[7] GND VDD SRAM_CELL
X_cell_17_8 WL17 BL[8] BLB[8] GND VDD SRAM_CELL
X_cell_17_9 WL17 BL[9] BLB[9] GND VDD SRAM_CELL
X_cell_17_10 WL17 BL[10] BLB[10] GND VDD SRAM_CELL
X_cell_17_11 WL17 BL[11] BLB[11] GND VDD SRAM_CELL
X_cell_17_12 WL17 BL[12] BLB[12] GND VDD SRAM_CELL
X_cell_17_13 WL17 BL[13] BLB[13] GND VDD SRAM_CELL
X_cell_17_14 WL17 BL[14] BLB[14] GND VDD SRAM_CELL
X_cell_17_15 WL17 BL[15] BLB[15] GND VDD SRAM_CELL
X_cell_17_16 WL17 BL[16] BLB[16] GND VDD SRAM_CELL
X_cell_17_17 WL17 BL[17] BLB[17] GND VDD SRAM_CELL
X_cell_17_18 WL17 BL[18] BLB[18] GND VDD SRAM_CELL
X_cell_17_19 WL17 BL[19] BLB[19] GND VDD SRAM_CELL
X_cell_17_20 WL17 BL[20] BLB[20] GND VDD SRAM_CELL
X_cell_17_21 WL17 BL[21] BLB[21] GND VDD SRAM_CELL
X_cell_17_22 WL17 BL[22] BLB[22] GND VDD SRAM_CELL
X_cell_17_23 WL17 BL[23] BLB[23] GND VDD SRAM_CELL
X_cell_17_24 WL17 BL[24] BLB[24] GND VDD SRAM_CELL
X_cell_17_25 WL17 BL[25] BLB[25] GND VDD SRAM_CELL
X_cell_17_26 WL17 BL[26] BLB[26] GND VDD SRAM_CELL
X_cell_17_27 WL17 BL[27] BLB[27] GND VDD SRAM_CELL
X_cell_17_28 WL17 BL[28] BLB[28] GND VDD SRAM_CELL
X_cell_17_29 WL17 BL[29] BLB[29] GND VDD SRAM_CELL
X_cell_17_30 WL17 BL[30] BLB[30] GND VDD SRAM_CELL
X_cell_17_31 WL17 BL[31] BLB[31] GND VDD SRAM_CELL
* Row 18
X_cell_18_0 WL18 BL[0] BLB[0] GND VDD SRAM_CELL
X_cell_18_1 WL18 BL[1] BLB[1] GND VDD SRAM_CELL
X_cell_18_2 WL18 BL[2] BLB[2] GND VDD SRAM_CELL
X_cell_18_3 WL18 BL[3] BLB[3] GND VDD SRAM_CELL
X_cell_18_4 WL18 BL[4] BLB[4] GND VDD SRAM_CELL
X_cell_18_5 WL18 BL[5] BLB[5] GND VDD SRAM_CELL
X_cell_18_6 WL18 BL[6] BLB[6] GND VDD SRAM_CELL
X_cell_18_7 WL18 BL[7] BLB[7] GND VDD SRAM_CELL
X_cell_18_8 WL18 BL[8] BLB[8] GND VDD SRAM_CELL
X_cell_18_9 WL18 BL[9] BLB[9] GND VDD SRAM_CELL
X_cell_18_10 WL18 BL[10] BLB[10] GND VDD SRAM_CELL
X_cell_18_11 WL18 BL[11] BLB[11] GND VDD SRAM_CELL
X_cell_18_12 WL18 BL[12] BLB[12] GND VDD SRAM_CELL
X_cell_18_13 WL18 BL[13] BLB[13] GND VDD SRAM_CELL
X_cell_18_14 WL18 BL[14] BLB[14] GND VDD SRAM_CELL
X_cell_18_15 WL18 BL[15] BLB[15] GND VDD SRAM_CELL
X_cell_18_16 WL18 BL[16] BLB[16] GND VDD SRAM_CELL
X_cell_18_17 WL18 BL[17] BLB[17] GND VDD SRAM_CELL
X_cell_18_18 WL18 BL[18] BLB[18] GND VDD SRAM_CELL
X_cell_18_19 WL18 BL[19] BLB[19] GND VDD SRAM_CELL
X_cell_18_20 WL18 BL[20] BLB[20] GND VDD SRAM_CELL
X_cell_18_21 WL18 BL[21] BLB[21] GND VDD SRAM_CELL
X_cell_18_22 WL18 BL[22] BLB[22] GND VDD SRAM_CELL
X_cell_18_23 WL18 BL[23] BLB[23] GND VDD SRAM_CELL
X_cell_18_24 WL18 BL[24] BLB[24] GND VDD SRAM_CELL
X_cell_18_25 WL18 BL[25] BLB[25] GND VDD SRAM_CELL
X_cell_18_26 WL18 BL[26] BLB[26] GND VDD SRAM_CELL
X_cell_18_27 WL18 BL[27] BLB[27] GND VDD SRAM_CELL
X_cell_18_28 WL18 BL[28] BLB[28] GND VDD SRAM_CELL
X_cell_18_29 WL18 BL[29] BLB[29] GND VDD SRAM_CELL
X_cell_18_30 WL18 BL[30] BLB[30] GND VDD SRAM_CELL
X_cell_18_31 WL18 BL[31] BLB[31] GND VDD SRAM_CELL
* Row 19
X_cell_19_0 WL19 BL[0] BLB[0] GND VDD SRAM_CELL
X_cell_19_1 WL19 BL[1] BLB[1] GND VDD SRAM_CELL
X_cell_19_2 WL19 BL[2] BLB[2] GND VDD SRAM_CELL
X_cell_19_3 WL19 BL[3] BLB[3] GND VDD SRAM_CELL
X_cell_19_4 WL19 BL[4] BLB[4] GND VDD SRAM_CELL
X_cell_19_5 WL19 BL[5] BLB[5] GND VDD SRAM_CELL
X_cell_19_6 WL19 BL[6] BLB[6] GND VDD SRAM_CELL
X_cell_19_7 WL19 BL[7] BLB[7] GND VDD SRAM_CELL
X_cell_19_8 WL19 BL[8] BLB[8] GND VDD SRAM_CELL
X_cell_19_9 WL19 BL[9] BLB[9] GND VDD SRAM_CELL
X_cell_19_10 WL19 BL[10] BLB[10] GND VDD SRAM_CELL
X_cell_19_11 WL19 BL[11] BLB[11] GND VDD SRAM_CELL
X_cell_19_12 WL19 BL[12] BLB[12] GND VDD SRAM_CELL
X_cell_19_13 WL19 BL[13] BLB[13] GND VDD SRAM_CELL
X_cell_19_14 WL19 BL[14] BLB[14] GND VDD SRAM_CELL
X_cell_19_15 WL19 BL[15] BLB[15] GND VDD SRAM_CELL
X_cell_19_16 WL19 BL[16] BLB[16] GND VDD SRAM_CELL
X_cell_19_17 WL19 BL[17] BLB[17] GND VDD SRAM_CELL
X_cell_19_18 WL19 BL[18] BLB[18] GND VDD SRAM_CELL
X_cell_19_19 WL19 BL[19] BLB[19] GND VDD SRAM_CELL
X_cell_19_20 WL19 BL[20] BLB[20] GND VDD SRAM_CELL
X_cell_19_21 WL19 BL[21] BLB[21] GND VDD SRAM_CELL
X_cell_19_22 WL19 BL[22] BLB[22] GND VDD SRAM_CELL
X_cell_19_23 WL19 BL[23] BLB[23] GND VDD SRAM_CELL
X_cell_19_24 WL19 BL[24] BLB[24] GND VDD SRAM_CELL
X_cell_19_25 WL19 BL[25] BLB[25] GND VDD SRAM_CELL
X_cell_19_26 WL19 BL[26] BLB[26] GND VDD SRAM_CELL
X_cell_19_27 WL19 BL[27] BLB[27] GND VDD SRAM_CELL
X_cell_19_28 WL19 BL[28] BLB[28] GND VDD SRAM_CELL
X_cell_19_29 WL19 BL[29] BLB[29] GND VDD SRAM_CELL
X_cell_19_30 WL19 BL[30] BLB[30] GND VDD SRAM_CELL
X_cell_19_31 WL19 BL[31] BLB[31] GND VDD SRAM_CELL
* Row 20
X_cell_20_0 WL20 BL[0] BLB[0] GND VDD SRAM_CELL
X_cell_20_1 WL20 BL[1] BLB[1] GND VDD SRAM_CELL
X_cell_20_2 WL20 BL[2] BLB[2] GND VDD SRAM_CELL
X_cell_20_3 WL20 BL[3] BLB[3] GND VDD SRAM_CELL
X_cell_20_4 WL20 BL[4] BLB[4] GND VDD SRAM_CELL
X_cell_20_5 WL20 BL[5] BLB[5] GND VDD SRAM_CELL
X_cell_20_6 WL20 BL[6] BLB[6] GND VDD SRAM_CELL
X_cell_20_7 WL20 BL[7] BLB[7] GND VDD SRAM_CELL
X_cell_20_8 WL20 BL[8] BLB[8] GND VDD SRAM_CELL
X_cell_20_9 WL20 BL[9] BLB[9] GND VDD SRAM_CELL
X_cell_20_10 WL20 BL[10] BLB[10] GND VDD SRAM_CELL
X_cell_20_11 WL20 BL[11] BLB[11] GND VDD SRAM_CELL
X_cell_20_12 WL20 BL[12] BLB[12] GND VDD SRAM_CELL
X_cell_20_13 WL20 BL[13] BLB[13] GND VDD SRAM_CELL
X_cell_20_14 WL20 BL[14] BLB[14] GND VDD SRAM_CELL
X_cell_20_15 WL20 BL[15] BLB[15] GND VDD SRAM_CELL
X_cell_20_16 WL20 BL[16] BLB[16] GND VDD SRAM_CELL
X_cell_20_17 WL20 BL[17] BLB[17] GND VDD SRAM_CELL
X_cell_20_18 WL20 BL[18] BLB[18] GND VDD SRAM_CELL
X_cell_20_19 WL20 BL[19] BLB[19] GND VDD SRAM_CELL
X_cell_20_20 WL20 BL[20] BLB[20] GND VDD SRAM_CELL
X_cell_20_21 WL20 BL[21] BLB[21] GND VDD SRAM_CELL
X_cell_20_22 WL20 BL[22] BLB[22] GND VDD SRAM_CELL
X_cell_20_23 WL20 BL[23] BLB[23] GND VDD SRAM_CELL
X_cell_20_24 WL20 BL[24] BLB[24] GND VDD SRAM_CELL
X_cell_20_25 WL20 BL[25] BLB[25] GND VDD SRAM_CELL
X_cell_20_26 WL20 BL[26] BLB[26] GND VDD SRAM_CELL
X_cell_20_27 WL20 BL[27] BLB[27] GND VDD SRAM_CELL
X_cell_20_28 WL20 BL[28] BLB[28] GND VDD SRAM_CELL
X_cell_20_29 WL20 BL[29] BLB[29] GND VDD SRAM_CELL
X_cell_20_30 WL20 BL[30] BLB[30] GND VDD SRAM_CELL
X_cell_20_31 WL20 BL[31] BLB[31] GND VDD SRAM_CELL
* Row 21
X_cell_21_0 WL21 BL[0] BLB[0] GND VDD SRAM_CELL
X_cell_21_1 WL21 BL[1] BLB[1] GND VDD SRAM_CELL
X_cell_21_2 WL21 BL[2] BLB[2] GND VDD SRAM_CELL
X_cell_21_3 WL21 BL[3] BLB[3] GND VDD SRAM_CELL
X_cell_21_4 WL21 BL[4] BLB[4] GND VDD SRAM_CELL
X_cell_21_5 WL21 BL[5] BLB[5] GND VDD SRAM_CELL
X_cell_21_6 WL21 BL[6] BLB[6] GND VDD SRAM_CELL
X_cell_21_7 WL21 BL[7] BLB[7] GND VDD SRAM_CELL
X_cell_21_8 WL21 BL[8] BLB[8] GND VDD SRAM_CELL
X_cell_21_9 WL21 BL[9] BLB[9] GND VDD SRAM_CELL
X_cell_21_10 WL21 BL[10] BLB[10] GND VDD SRAM_CELL
X_cell_21_11 WL21 BL[11] BLB[11] GND VDD SRAM_CELL
X_cell_21_12 WL21 BL[12] BLB[12] GND VDD SRAM_CELL
X_cell_21_13 WL21 BL[13] BLB[13] GND VDD SRAM_CELL
X_cell_21_14 WL21 BL[14] BLB[14] GND VDD SRAM_CELL
X_cell_21_15 WL21 BL[15] BLB[15] GND VDD SRAM_CELL
X_cell_21_16 WL21 BL[16] BLB[16] GND VDD SRAM_CELL
X_cell_21_17 WL21 BL[17] BLB[17] GND VDD SRAM_CELL
X_cell_21_18 WL21 BL[18] BLB[18] GND VDD SRAM_CELL
X_cell_21_19 WL21 BL[19] BLB[19] GND VDD SRAM_CELL
X_cell_21_20 WL21 BL[20] BLB[20] GND VDD SRAM_CELL
X_cell_21_21 WL21 BL[21] BLB[21] GND VDD SRAM_CELL
X_cell_21_22 WL21 BL[22] BLB[22] GND VDD SRAM_CELL
X_cell_21_23 WL21 BL[23] BLB[23] GND VDD SRAM_CELL
X_cell_21_24 WL21 BL[24] BLB[24] GND VDD SRAM_CELL
X_cell_21_25 WL21 BL[25] BLB[25] GND VDD SRAM_CELL
X_cell_21_26 WL21 BL[26] BLB[26] GND VDD SRAM_CELL
X_cell_21_27 WL21 BL[27] BLB[27] GND VDD SRAM_CELL
X_cell_21_28 WL21 BL[28] BLB[28] GND VDD SRAM_CELL
X_cell_21_29 WL21 BL[29] BLB[29] GND VDD SRAM_CELL
X_cell_21_30 WL21 BL[30] BLB[30] GND VDD SRAM_CELL
X_cell_21_31 WL21 BL[31] BLB[31] GND VDD SRAM_CELL
* Row 22
X_cell_22_0 WL22 BL[0] BLB[0] GND VDD SRAM_CELL
X_cell_22_1 WL22 BL[1] BLB[1] GND VDD SRAM_CELL
X_cell_22_2 WL22 BL[2] BLB[2] GND VDD SRAM_CELL
X_cell_22_3 WL22 BL[3] BLB[3] GND VDD SRAM_CELL
X_cell_22_4 WL22 BL[4] BLB[4] GND VDD SRAM_CELL
X_cell_22_5 WL22 BL[5] BLB[5] GND VDD SRAM_CELL
X_cell_22_6 WL22 BL[6] BLB[6] GND VDD SRAM_CELL
X_cell_22_7 WL22 BL[7] BLB[7] GND VDD SRAM_CELL
X_cell_22_8 WL22 BL[8] BLB[8] GND VDD SRAM_CELL
X_cell_22_9 WL22 BL[9] BLB[9] GND VDD SRAM_CELL
X_cell_22_10 WL22 BL[10] BLB[10] GND VDD SRAM_CELL
X_cell_22_11 WL22 BL[11] BLB[11] GND VDD SRAM_CELL
X_cell_22_12 WL22 BL[12] BLB[12] GND VDD SRAM_CELL
X_cell_22_13 WL22 BL[13] BLB[13] GND VDD SRAM_CELL
X_cell_22_14 WL22 BL[14] BLB[14] GND VDD SRAM_CELL
X_cell_22_15 WL22 BL[15] BLB[15] GND VDD SRAM_CELL
X_cell_22_16 WL22 BL[16] BLB[16] GND VDD SRAM_CELL
X_cell_22_17 WL22 BL[17] BLB[17] GND VDD SRAM_CELL
X_cell_22_18 WL22 BL[18] BLB[18] GND VDD SRAM_CELL
X_cell_22_19 WL22 BL[19] BLB[19] GND VDD SRAM_CELL
X_cell_22_20 WL22 BL[20] BLB[20] GND VDD SRAM_CELL
X_cell_22_21 WL22 BL[21] BLB[21] GND VDD SRAM_CELL
X_cell_22_22 WL22 BL[22] BLB[22] GND VDD SRAM_CELL
X_cell_22_23 WL22 BL[23] BLB[23] GND VDD SRAM_CELL
X_cell_22_24 WL22 BL[24] BLB[24] GND VDD SRAM_CELL
X_cell_22_25 WL22 BL[25] BLB[25] GND VDD SRAM_CELL
X_cell_22_26 WL22 BL[26] BLB[26] GND VDD SRAM_CELL
X_cell_22_27 WL22 BL[27] BLB[27] GND VDD SRAM_CELL
X_cell_22_28 WL22 BL[28] BLB[28] GND VDD SRAM_CELL
X_cell_22_29 WL22 BL[29] BLB[29] GND VDD SRAM_CELL
X_cell_22_30 WL22 BL[30] BLB[30] GND VDD SRAM_CELL
X_cell_22_31 WL22 BL[31] BLB[31] GND VDD SRAM_CELL
* Row 23
X_cell_23_0 WL23 BL[0] BLB[0] GND VDD SRAM_CELL
X_cell_23_1 WL23 BL[1] BLB[1] GND VDD SRAM_CELL
X_cell_23_2 WL23 BL[2] BLB[2] GND VDD SRAM_CELL
X_cell_23_3 WL23 BL[3] BLB[3] GND VDD SRAM_CELL
X_cell_23_4 WL23 BL[4] BLB[4] GND VDD SRAM_CELL
X_cell_23_5 WL23 BL[5] BLB[5] GND VDD SRAM_CELL
X_cell_23_6 WL23 BL[6] BLB[6] GND VDD SRAM_CELL
X_cell_23_7 WL23 BL[7] BLB[7] GND VDD SRAM_CELL
X_cell_23_8 WL23 BL[8] BLB[8] GND VDD SRAM_CELL
X_cell_23_9 WL23 BL[9] BLB[9] GND VDD SRAM_CELL
X_cell_23_10 WL23 BL[10] BLB[10] GND VDD SRAM_CELL
X_cell_23_11 WL23 BL[11] BLB[11] GND VDD SRAM_CELL
X_cell_23_12 WL23 BL[12] BLB[12] GND VDD SRAM_CELL
X_cell_23_13 WL23 BL[13] BLB[13] GND VDD SRAM_CELL
X_cell_23_14 WL23 BL[14] BLB[14] GND VDD SRAM_CELL
X_cell_23_15 WL23 BL[15] BLB[15] GND VDD SRAM_CELL
X_cell_23_16 WL23 BL[16] BLB[16] GND VDD SRAM_CELL
X_cell_23_17 WL23 BL[17] BLB[17] GND VDD SRAM_CELL
X_cell_23_18 WL23 BL[18] BLB[18] GND VDD SRAM_CELL
X_cell_23_19 WL23 BL[19] BLB[19] GND VDD SRAM_CELL
X_cell_23_20 WL23 BL[20] BLB[20] GND VDD SRAM_CELL
X_cell_23_21 WL23 BL[21] BLB[21] GND VDD SRAM_CELL
X_cell_23_22 WL23 BL[22] BLB[22] GND VDD SRAM_CELL
X_cell_23_23 WL23 BL[23] BLB[23] GND VDD SRAM_CELL
X_cell_23_24 WL23 BL[24] BLB[24] GND VDD SRAM_CELL
X_cell_23_25 WL23 BL[25] BLB[25] GND VDD SRAM_CELL
X_cell_23_26 WL23 BL[26] BLB[26] GND VDD SRAM_CELL
X_cell_23_27 WL23 BL[27] BLB[27] GND VDD SRAM_CELL
X_cell_23_28 WL23 BL[28] BLB[28] GND VDD SRAM_CELL
X_cell_23_29 WL23 BL[29] BLB[29] GND VDD SRAM_CELL
X_cell_23_30 WL23 BL[30] BLB[30] GND VDD SRAM_CELL
X_cell_23_31 WL23 BL[31] BLB[31] GND VDD SRAM_CELL
* Row 24
X_cell_24_0 WL24 BL[0] BLB[0] GND VDD SRAM_CELL
X_cell_24_1 WL24 BL[1] BLB[1] GND VDD SRAM_CELL
X_cell_24_2 WL24 BL[2] BLB[2] GND VDD SRAM_CELL
X_cell_24_3 WL24 BL[3] BLB[3] GND VDD SRAM_CELL
X_cell_24_4 WL24 BL[4] BLB[4] GND VDD SRAM_CELL
X_cell_24_5 WL24 BL[5] BLB[5] GND VDD SRAM_CELL
X_cell_24_6 WL24 BL[6] BLB[6] GND VDD SRAM_CELL
X_cell_24_7 WL24 BL[7] BLB[7] GND VDD SRAM_CELL
X_cell_24_8 WL24 BL[8] BLB[8] GND VDD SRAM_CELL
X_cell_24_9 WL24 BL[9] BLB[9] GND VDD SRAM_CELL
X_cell_24_10 WL24 BL[10] BLB[10] GND VDD SRAM_CELL
X_cell_24_11 WL24 BL[11] BLB[11] GND VDD SRAM_CELL
X_cell_24_12 WL24 BL[12] BLB[12] GND VDD SRAM_CELL
X_cell_24_13 WL24 BL[13] BLB[13] GND VDD SRAM_CELL
X_cell_24_14 WL24 BL[14] BLB[14] GND VDD SRAM_CELL
X_cell_24_15 WL24 BL[15] BLB[15] GND VDD SRAM_CELL
X_cell_24_16 WL24 BL[16] BLB[16] GND VDD SRAM_CELL
X_cell_24_17 WL24 BL[17] BLB[17] GND VDD SRAM_CELL
X_cell_24_18 WL24 BL[18] BLB[18] GND VDD SRAM_CELL
X_cell_24_19 WL24 BL[19] BLB[19] GND VDD SRAM_CELL
X_cell_24_20 WL24 BL[20] BLB[20] GND VDD SRAM_CELL
X_cell_24_21 WL24 BL[21] BLB[21] GND VDD SRAM_CELL
X_cell_24_22 WL24 BL[22] BLB[22] GND VDD SRAM_CELL
X_cell_24_23 WL24 BL[23] BLB[23] GND VDD SRAM_CELL
X_cell_24_24 WL24 BL[24] BLB[24] GND VDD SRAM_CELL
X_cell_24_25 WL24 BL[25] BLB[25] GND VDD SRAM_CELL
X_cell_24_26 WL24 BL[26] BLB[26] GND VDD SRAM_CELL
X_cell_24_27 WL24 BL[27] BLB[27] GND VDD SRAM_CELL
X_cell_24_28 WL24 BL[28] BLB[28] GND VDD SRAM_CELL
X_cell_24_29 WL24 BL[29] BLB[29] GND VDD SRAM_CELL
X_cell_24_30 WL24 BL[30] BLB[30] GND VDD SRAM_CELL
X_cell_24_31 WL24 BL[31] BLB[31] GND VDD SRAM_CELL
* Row 25
X_cell_25_0 WL25 BL[0] BLB[0] GND VDD SRAM_CELL
X_cell_25_1 WL25 BL[1] BLB[1] GND VDD SRAM_CELL
X_cell_25_2 WL25 BL[2] BLB[2] GND VDD SRAM_CELL
X_cell_25_3 WL25 BL[3] BLB[3] GND VDD SRAM_CELL
X_cell_25_4 WL25 BL[4] BLB[4] GND VDD SRAM_CELL
X_cell_25_5 WL25 BL[5] BLB[5] GND VDD SRAM_CELL
X_cell_25_6 WL25 BL[6] BLB[6] GND VDD SRAM_CELL
X_cell_25_7 WL25 BL[7] BLB[7] GND VDD SRAM_CELL
X_cell_25_8 WL25 BL[8] BLB[8] GND VDD SRAM_CELL
X_cell_25_9 WL25 BL[9] BLB[9] GND VDD SRAM_CELL
X_cell_25_10 WL25 BL[10] BLB[10] GND VDD SRAM_CELL
X_cell_25_11 WL25 BL[11] BLB[11] GND VDD SRAM_CELL
X_cell_25_12 WL25 BL[12] BLB[12] GND VDD SRAM_CELL
X_cell_25_13 WL25 BL[13] BLB[13] GND VDD SRAM_CELL
X_cell_25_14 WL25 BL[14] BLB[14] GND VDD SRAM_CELL
X_cell_25_15 WL25 BL[15] BLB[15] GND VDD SRAM_CELL
X_cell_25_16 WL25 BL[16] BLB[16] GND VDD SRAM_CELL
X_cell_25_17 WL25 BL[17] BLB[17] GND VDD SRAM_CELL
X_cell_25_18 WL25 BL[18] BLB[18] GND VDD SRAM_CELL
X_cell_25_19 WL25 BL[19] BLB[19] GND VDD SRAM_CELL
X_cell_25_20 WL25 BL[20] BLB[20] GND VDD SRAM_CELL
X_cell_25_21 WL25 BL[21] BLB[21] GND VDD SRAM_CELL
X_cell_25_22 WL25 BL[22] BLB[22] GND VDD SRAM_CELL
X_cell_25_23 WL25 BL[23] BLB[23] GND VDD SRAM_CELL
X_cell_25_24 WL25 BL[24] BLB[24] GND VDD SRAM_CELL
X_cell_25_25 WL25 BL[25] BLB[25] GND VDD SRAM_CELL
X_cell_25_26 WL25 BL[26] BLB[26] GND VDD SRAM_CELL
X_cell_25_27 WL25 BL[27] BLB[27] GND VDD SRAM_CELL
X_cell_25_28 WL25 BL[28] BLB[28] GND VDD SRAM_CELL
X_cell_25_29 WL25 BL[29] BLB[29] GND VDD SRAM_CELL
X_cell_25_30 WL25 BL[30] BLB[30] GND VDD SRAM_CELL
X_cell_25_31 WL25 BL[31] BLB[31] GND VDD SRAM_CELL
* Row 26
X_cell_26_0 WL26 BL[0] BLB[0] GND VDD SRAM_CELL
X_cell_26_1 WL26 BL[1] BLB[1] GND VDD SRAM_CELL
X_cell_26_2 WL26 BL[2] BLB[2] GND VDD SRAM_CELL
X_cell_26_3 WL26 BL[3] BLB[3] GND VDD SRAM_CELL
X_cell_26_4 WL26 BL[4] BLB[4] GND VDD SRAM_CELL
X_cell_26_5 WL26 BL[5] BLB[5] GND VDD SRAM_CELL
X_cell_26_6 WL26 BL[6] BLB[6] GND VDD SRAM_CELL
X_cell_26_7 WL26 BL[7] BLB[7] GND VDD SRAM_CELL
X_cell_26_8 WL26 BL[8] BLB[8] GND VDD SRAM_CELL
X_cell_26_9 WL26 BL[9] BLB[9] GND VDD SRAM_CELL
X_cell_26_10 WL26 BL[10] BLB[10] GND VDD SRAM_CELL
X_cell_26_11 WL26 BL[11] BLB[11] GND VDD SRAM_CELL
X_cell_26_12 WL26 BL[12] BLB[12] GND VDD SRAM_CELL
X_cell_26_13 WL26 BL[13] BLB[13] GND VDD SRAM_CELL
X_cell_26_14 WL26 BL[14] BLB[14] GND VDD SRAM_CELL
X_cell_26_15 WL26 BL[15] BLB[15] GND VDD SRAM_CELL
X_cell_26_16 WL26 BL[16] BLB[16] GND VDD SRAM_CELL
X_cell_26_17 WL26 BL[17] BLB[17] GND VDD SRAM_CELL
X_cell_26_18 WL26 BL[18] BLB[18] GND VDD SRAM_CELL
X_cell_26_19 WL26 BL[19] BLB[19] GND VDD SRAM_CELL
X_cell_26_20 WL26 BL[20] BLB[20] GND VDD SRAM_CELL
X_cell_26_21 WL26 BL[21] BLB[21] GND VDD SRAM_CELL
X_cell_26_22 WL26 BL[22] BLB[22] GND VDD SRAM_CELL
X_cell_26_23 WL26 BL[23] BLB[23] GND VDD SRAM_CELL
X_cell_26_24 WL26 BL[24] BLB[24] GND VDD SRAM_CELL
X_cell_26_25 WL26 BL[25] BLB[25] GND VDD SRAM_CELL
X_cell_26_26 WL26 BL[26] BLB[26] GND VDD SRAM_CELL
X_cell_26_27 WL26 BL[27] BLB[27] GND VDD SRAM_CELL
X_cell_26_28 WL26 BL[28] BLB[28] GND VDD SRAM_CELL
X_cell_26_29 WL26 BL[29] BLB[29] GND VDD SRAM_CELL
X_cell_26_30 WL26 BL[30] BLB[30] GND VDD SRAM_CELL
X_cell_26_31 WL26 BL[31] BLB[31] GND VDD SRAM_CELL
* Row 27
X_cell_27_0 WL27 BL[0] BLB[0] GND VDD SRAM_CELL
X_cell_27_1 WL27 BL[1] BLB[1] GND VDD SRAM_CELL
X_cell_27_2 WL27 BL[2] BLB[2] GND VDD SRAM_CELL
X_cell_27_3 WL27 BL[3] BLB[3] GND VDD SRAM_CELL
X_cell_27_4 WL27 BL[4] BLB[4] GND VDD SRAM_CELL
X_cell_27_5 WL27 BL[5] BLB[5] GND VDD SRAM_CELL
X_cell_27_6 WL27 BL[6] BLB[6] GND VDD SRAM_CELL
X_cell_27_7 WL27 BL[7] BLB[7] GND VDD SRAM_CELL
X_cell_27_8 WL27 BL[8] BLB[8] GND VDD SRAM_CELL
X_cell_27_9 WL27 BL[9] BLB[9] GND VDD SRAM_CELL
X_cell_27_10 WL27 BL[10] BLB[10] GND VDD SRAM_CELL
X_cell_27_11 WL27 BL[11] BLB[11] GND VDD SRAM_CELL
X_cell_27_12 WL27 BL[12] BLB[12] GND VDD SRAM_CELL
X_cell_27_13 WL27 BL[13] BLB[13] GND VDD SRAM_CELL
X_cell_27_14 WL27 BL[14] BLB[14] GND VDD SRAM_CELL
X_cell_27_15 WL27 BL[15] BLB[15] GND VDD SRAM_CELL
X_cell_27_16 WL27 BL[16] BLB[16] GND VDD SRAM_CELL
X_cell_27_17 WL27 BL[17] BLB[17] GND VDD SRAM_CELL
X_cell_27_18 WL27 BL[18] BLB[18] GND VDD SRAM_CELL
X_cell_27_19 WL27 BL[19] BLB[19] GND VDD SRAM_CELL
X_cell_27_20 WL27 BL[20] BLB[20] GND VDD SRAM_CELL
X_cell_27_21 WL27 BL[21] BLB[21] GND VDD SRAM_CELL
X_cell_27_22 WL27 BL[22] BLB[22] GND VDD SRAM_CELL
X_cell_27_23 WL27 BL[23] BLB[23] GND VDD SRAM_CELL
X_cell_27_24 WL27 BL[24] BLB[24] GND VDD SRAM_CELL
X_cell_27_25 WL27 BL[25] BLB[25] GND VDD SRAM_CELL
X_cell_27_26 WL27 BL[26] BLB[26] GND VDD SRAM_CELL
X_cell_27_27 WL27 BL[27] BLB[27] GND VDD SRAM_CELL
X_cell_27_28 WL27 BL[28] BLB[28] GND VDD SRAM_CELL
X_cell_27_29 WL27 BL[29] BLB[29] GND VDD SRAM_CELL
X_cell_27_30 WL27 BL[30] BLB[30] GND VDD SRAM_CELL
X_cell_27_31 WL27 BL[31] BLB[31] GND VDD SRAM_CELL
* Row 28
X_cell_28_0 WL28 BL[0] BLB[0] GND VDD SRAM_CELL
X_cell_28_1 WL28 BL[1] BLB[1] GND VDD SRAM_CELL
X_cell_28_2 WL28 BL[2] BLB[2] GND VDD SRAM_CELL
X_cell_28_3 WL28 BL[3] BLB[3] GND VDD SRAM_CELL
X_cell_28_4 WL28 BL[4] BLB[4] GND VDD SRAM_CELL
X_cell_28_5 WL28 BL[5] BLB[5] GND VDD SRAM_CELL
X_cell_28_6 WL28 BL[6] BLB[6] GND VDD SRAM_CELL
X_cell_28_7 WL28 BL[7] BLB[7] GND VDD SRAM_CELL
X_cell_28_8 WL28 BL[8] BLB[8] GND VDD SRAM_CELL
X_cell_28_9 WL28 BL[9] BLB[9] GND VDD SRAM_CELL
X_cell_28_10 WL28 BL[10] BLB[10] GND VDD SRAM_CELL
X_cell_28_11 WL28 BL[11] BLB[11] GND VDD SRAM_CELL
X_cell_28_12 WL28 BL[12] BLB[12] GND VDD SRAM_CELL
X_cell_28_13 WL28 BL[13] BLB[13] GND VDD SRAM_CELL
X_cell_28_14 WL28 BL[14] BLB[14] GND VDD SRAM_CELL
X_cell_28_15 WL28 BL[15] BLB[15] GND VDD SRAM_CELL
X_cell_28_16 WL28 BL[16] BLB[16] GND VDD SRAM_CELL
X_cell_28_17 WL28 BL[17] BLB[17] GND VDD SRAM_CELL
X_cell_28_18 WL28 BL[18] BLB[18] GND VDD SRAM_CELL
X_cell_28_19 WL28 BL[19] BLB[19] GND VDD SRAM_CELL
X_cell_28_20 WL28 BL[20] BLB[20] GND VDD SRAM_CELL
X_cell_28_21 WL28 BL[21] BLB[21] GND VDD SRAM_CELL
X_cell_28_22 WL28 BL[22] BLB[22] GND VDD SRAM_CELL
X_cell_28_23 WL28 BL[23] BLB[23] GND VDD SRAM_CELL
X_cell_28_24 WL28 BL[24] BLB[24] GND VDD SRAM_CELL
X_cell_28_25 WL28 BL[25] BLB[25] GND VDD SRAM_CELL
X_cell_28_26 WL28 BL[26] BLB[26] GND VDD SRAM_CELL
X_cell_28_27 WL28 BL[27] BLB[27] GND VDD SRAM_CELL
X_cell_28_28 WL28 BL[28] BLB[28] GND VDD SRAM_CELL
X_cell_28_29 WL28 BL[29] BLB[29] GND VDD SRAM_CELL
X_cell_28_30 WL28 BL[30] BLB[30] GND VDD SRAM_CELL
X_cell_28_31 WL28 BL[31] BLB[31] GND VDD SRAM_CELL
* Row 29
X_cell_29_0 WL29 BL[0] BLB[0] GND VDD SRAM_CELL
X_cell_29_1 WL29 BL[1] BLB[1] GND VDD SRAM_CELL
X_cell_29_2 WL29 BL[2] BLB[2] GND VDD SRAM_CELL
X_cell_29_3 WL29 BL[3] BLB[3] GND VDD SRAM_CELL
X_cell_29_4 WL29 BL[4] BLB[4] GND VDD SRAM_CELL
X_cell_29_5 WL29 BL[5] BLB[5] GND VDD SRAM_CELL
X_cell_29_6 WL29 BL[6] BLB[6] GND VDD SRAM_CELL
X_cell_29_7 WL29 BL[7] BLB[7] GND VDD SRAM_CELL
X_cell_29_8 WL29 BL[8] BLB[8] GND VDD SRAM_CELL
X_cell_29_9 WL29 BL[9] BLB[9] GND VDD SRAM_CELL
X_cell_29_10 WL29 BL[10] BLB[10] GND VDD SRAM_CELL
X_cell_29_11 WL29 BL[11] BLB[11] GND VDD SRAM_CELL
X_cell_29_12 WL29 BL[12] BLB[12] GND VDD SRAM_CELL
X_cell_29_13 WL29 BL[13] BLB[13] GND VDD SRAM_CELL
X_cell_29_14 WL29 BL[14] BLB[14] GND VDD SRAM_CELL
X_cell_29_15 WL29 BL[15] BLB[15] GND VDD SRAM_CELL
X_cell_29_16 WL29 BL[16] BLB[16] GND VDD SRAM_CELL
X_cell_29_17 WL29 BL[17] BLB[17] GND VDD SRAM_CELL
X_cell_29_18 WL29 BL[18] BLB[18] GND VDD SRAM_CELL
X_cell_29_19 WL29 BL[19] BLB[19] GND VDD SRAM_CELL
X_cell_29_20 WL29 BL[20] BLB[20] GND VDD SRAM_CELL
X_cell_29_21 WL29 BL[21] BLB[21] GND VDD SRAM_CELL
X_cell_29_22 WL29 BL[22] BLB[22] GND VDD SRAM_CELL
X_cell_29_23 WL29 BL[23] BLB[23] GND VDD SRAM_CELL
X_cell_29_24 WL29 BL[24] BLB[24] GND VDD SRAM_CELL
X_cell_29_25 WL29 BL[25] BLB[25] GND VDD SRAM_CELL
X_cell_29_26 WL29 BL[26] BLB[26] GND VDD SRAM_CELL
X_cell_29_27 WL29 BL[27] BLB[27] GND VDD SRAM_CELL
X_cell_29_28 WL29 BL[28] BLB[28] GND VDD SRAM_CELL
X_cell_29_29 WL29 BL[29] BLB[29] GND VDD SRAM_CELL
X_cell_29_30 WL29 BL[30] BLB[30] GND VDD SRAM_CELL
X_cell_29_31 WL29 BL[31] BLB[31] GND VDD SRAM_CELL
* Row 30
X_cell_30_0 WL30 BL[0] BLB[0] GND VDD SRAM_CELL
X_cell_30_1 WL30 BL[1] BLB[1] GND VDD SRAM_CELL
X_cell_30_2 WL30 BL[2] BLB[2] GND VDD SRAM_CELL
X_cell_30_3 WL30 BL[3] BLB[3] GND VDD SRAM_CELL
X_cell_30_4 WL30 BL[4] BLB[4] GND VDD SRAM_CELL
X_cell_30_5 WL30 BL[5] BLB[5] GND VDD SRAM_CELL
X_cell_30_6 WL30 BL[6] BLB[6] GND VDD SRAM_CELL
X_cell_30_7 WL30 BL[7] BLB[7] GND VDD SRAM_CELL
X_cell_30_8 WL30 BL[8] BLB[8] GND VDD SRAM_CELL
X_cell_30_9 WL30 BL[9] BLB[9] GND VDD SRAM_CELL
X_cell_30_10 WL30 BL[10] BLB[10] GND VDD SRAM_CELL
X_cell_30_11 WL30 BL[11] BLB[11] GND VDD SRAM_CELL
X_cell_30_12 WL30 BL[12] BLB[12] GND VDD SRAM_CELL
X_cell_30_13 WL30 BL[13] BLB[13] GND VDD SRAM_CELL
X_cell_30_14 WL30 BL[14] BLB[14] GND VDD SRAM_CELL
X_cell_30_15 WL30 BL[15] BLB[15] GND VDD SRAM_CELL
X_cell_30_16 WL30 BL[16] BLB[16] GND VDD SRAM_CELL
X_cell_30_17 WL30 BL[17] BLB[17] GND VDD SRAM_CELL
X_cell_30_18 WL30 BL[18] BLB[18] GND VDD SRAM_CELL
X_cell_30_19 WL30 BL[19] BLB[19] GND VDD SRAM_CELL
X_cell_30_20 WL30 BL[20] BLB[20] GND VDD SRAM_CELL
X_cell_30_21 WL30 BL[21] BLB[21] GND VDD SRAM_CELL
X_cell_30_22 WL30 BL[22] BLB[22] GND VDD SRAM_CELL
X_cell_30_23 WL30 BL[23] BLB[23] GND VDD SRAM_CELL
X_cell_30_24 WL30 BL[24] BLB[24] GND VDD SRAM_CELL
X_cell_30_25 WL30 BL[25] BLB[25] GND VDD SRAM_CELL
X_cell_30_26 WL30 BL[26] BLB[26] GND VDD SRAM_CELL
X_cell_30_27 WL30 BL[27] BLB[27] GND VDD SRAM_CELL
X_cell_30_28 WL30 BL[28] BLB[28] GND VDD SRAM_CELL
X_cell_30_29 WL30 BL[29] BLB[29] GND VDD SRAM_CELL
X_cell_30_30 WL30 BL[30] BLB[30] GND VDD SRAM_CELL
X_cell_30_31 WL30 BL[31] BLB[31] GND VDD SRAM_CELL
* Row 31
X_cell_31_0 WL31 BL[0] BLB[0] GND VDD SRAM_CELL
X_cell_31_1 WL31 BL[1] BLB[1] GND VDD SRAM_CELL
X_cell_31_2 WL31 BL[2] BLB[2] GND VDD SRAM_CELL
X_cell_31_3 WL31 BL[3] BLB[3] GND VDD SRAM_CELL
X_cell_31_4 WL31 BL[4] BLB[4] GND VDD SRAM_CELL
X_cell_31_5 WL31 BL[5] BLB[5] GND VDD SRAM_CELL
X_cell_31_6 WL31 BL[6] BLB[6] GND VDD SRAM_CELL
X_cell_31_7 WL31 BL[7] BLB[7] GND VDD SRAM_CELL
X_cell_31_8 WL31 BL[8] BLB[8] GND VDD SRAM_CELL
X_cell_31_9 WL31 BL[9] BLB[9] GND VDD SRAM_CELL
X_cell_31_10 WL31 BL[10] BLB[10] GND VDD SRAM_CELL
X_cell_31_11 WL31 BL[11] BLB[11] GND VDD SRAM_CELL
X_cell_31_12 WL31 BL[12] BLB[12] GND VDD SRAM_CELL
X_cell_31_13 WL31 BL[13] BLB[13] GND VDD SRAM_CELL
X_cell_31_14 WL31 BL[14] BLB[14] GND VDD SRAM_CELL
X_cell_31_15 WL31 BL[15] BLB[15] GND VDD SRAM_CELL
X_cell_31_16 WL31 BL[16] BLB[16] GND VDD SRAM_CELL
X_cell_31_17 WL31 BL[17] BLB[17] GND VDD SRAM_CELL
X_cell_31_18 WL31 BL[18] BLB[18] GND VDD SRAM_CELL
X_cell_31_19 WL31 BL[19] BLB[19] GND VDD SRAM_CELL
X_cell_31_20 WL31 BL[20] BLB[20] GND VDD SRAM_CELL
X_cell_31_21 WL31 BL[21] BLB[21] GND VDD SRAM_CELL
X_cell_31_22 WL31 BL[22] BLB[22] GND VDD SRAM_CELL
X_cell_31_23 WL31 BL[23] BLB[23] GND VDD SRAM_CELL
X_cell_31_24 WL31 BL[24] BLB[24] GND VDD SRAM_CELL
X_cell_31_25 WL31 BL[25] BLB[25] GND VDD SRAM_CELL
X_cell_31_26 WL31 BL[26] BLB[26] GND VDD SRAM_CELL
X_cell_31_27 WL31 BL[27] BLB[27] GND VDD SRAM_CELL
X_cell_31_28 WL31 BL[28] BLB[28] GND VDD SRAM_CELL
X_cell_31_29 WL31 BL[29] BLB[29] GND VDD SRAM_CELL
X_cell_31_30 WL31 BL[30] BLB[30] GND VDD SRAM_CELL
X_cell_31_31 WL31 BL[31] BLB[31] GND VDD SRAM_CELL
* Row 32
X_cell_32_0 WL32 BL[0] BLB[0] GND VDD SRAM_CELL
X_cell_32_1 WL32 BL[1] BLB[1] GND VDD SRAM_CELL
X_cell_32_2 WL32 BL[2] BLB[2] GND VDD SRAM_CELL
X_cell_32_3 WL32 BL[3] BLB[3] GND VDD SRAM_CELL
X_cell_32_4 WL32 BL[4] BLB[4] GND VDD SRAM_CELL
X_cell_32_5 WL32 BL[5] BLB[5] GND VDD SRAM_CELL
X_cell_32_6 WL32 BL[6] BLB[6] GND VDD SRAM_CELL
X_cell_32_7 WL32 BL[7] BLB[7] GND VDD SRAM_CELL
X_cell_32_8 WL32 BL[8] BLB[8] GND VDD SRAM_CELL
X_cell_32_9 WL32 BL[9] BLB[9] GND VDD SRAM_CELL
X_cell_32_10 WL32 BL[10] BLB[10] GND VDD SRAM_CELL
X_cell_32_11 WL32 BL[11] BLB[11] GND VDD SRAM_CELL
X_cell_32_12 WL32 BL[12] BLB[12] GND VDD SRAM_CELL
X_cell_32_13 WL32 BL[13] BLB[13] GND VDD SRAM_CELL
X_cell_32_14 WL32 BL[14] BLB[14] GND VDD SRAM_CELL
X_cell_32_15 WL32 BL[15] BLB[15] GND VDD SRAM_CELL
X_cell_32_16 WL32 BL[16] BLB[16] GND VDD SRAM_CELL
X_cell_32_17 WL32 BL[17] BLB[17] GND VDD SRAM_CELL
X_cell_32_18 WL32 BL[18] BLB[18] GND VDD SRAM_CELL
X_cell_32_19 WL32 BL[19] BLB[19] GND VDD SRAM_CELL
X_cell_32_20 WL32 BL[20] BLB[20] GND VDD SRAM_CELL
X_cell_32_21 WL32 BL[21] BLB[21] GND VDD SRAM_CELL
X_cell_32_22 WL32 BL[22] BLB[22] GND VDD SRAM_CELL
X_cell_32_23 WL32 BL[23] BLB[23] GND VDD SRAM_CELL
X_cell_32_24 WL32 BL[24] BLB[24] GND VDD SRAM_CELL
X_cell_32_25 WL32 BL[25] BLB[25] GND VDD SRAM_CELL
X_cell_32_26 WL32 BL[26] BLB[26] GND VDD SRAM_CELL
X_cell_32_27 WL32 BL[27] BLB[27] GND VDD SRAM_CELL
X_cell_32_28 WL32 BL[28] BLB[28] GND VDD SRAM_CELL
X_cell_32_29 WL32 BL[29] BLB[29] GND VDD SRAM_CELL
X_cell_32_30 WL32 BL[30] BLB[30] GND VDD SRAM_CELL
X_cell_32_31 WL32 BL[31] BLB[31] GND VDD SRAM_CELL
* Row 33
X_cell_33_0 WL33 BL[0] BLB[0] GND VDD SRAM_CELL
X_cell_33_1 WL33 BL[1] BLB[1] GND VDD SRAM_CELL
X_cell_33_2 WL33 BL[2] BLB[2] GND VDD SRAM_CELL
X_cell_33_3 WL33 BL[3] BLB[3] GND VDD SRAM_CELL
X_cell_33_4 WL33 BL[4] BLB[4] GND VDD SRAM_CELL
X_cell_33_5 WL33 BL[5] BLB[5] GND VDD SRAM_CELL
X_cell_33_6 WL33 BL[6] BLB[6] GND VDD SRAM_CELL
X_cell_33_7 WL33 BL[7] BLB[7] GND VDD SRAM_CELL
X_cell_33_8 WL33 BL[8] BLB[8] GND VDD SRAM_CELL
X_cell_33_9 WL33 BL[9] BLB[9] GND VDD SRAM_CELL
X_cell_33_10 WL33 BL[10] BLB[10] GND VDD SRAM_CELL
X_cell_33_11 WL33 BL[11] BLB[11] GND VDD SRAM_CELL
X_cell_33_12 WL33 BL[12] BLB[12] GND VDD SRAM_CELL
X_cell_33_13 WL33 BL[13] BLB[13] GND VDD SRAM_CELL
X_cell_33_14 WL33 BL[14] BLB[14] GND VDD SRAM_CELL
X_cell_33_15 WL33 BL[15] BLB[15] GND VDD SRAM_CELL
X_cell_33_16 WL33 BL[16] BLB[16] GND VDD SRAM_CELL
X_cell_33_17 WL33 BL[17] BLB[17] GND VDD SRAM_CELL
X_cell_33_18 WL33 BL[18] BLB[18] GND VDD SRAM_CELL
X_cell_33_19 WL33 BL[19] BLB[19] GND VDD SRAM_CELL
X_cell_33_20 WL33 BL[20] BLB[20] GND VDD SRAM_CELL
X_cell_33_21 WL33 BL[21] BLB[21] GND VDD SRAM_CELL
X_cell_33_22 WL33 BL[22] BLB[22] GND VDD SRAM_CELL
X_cell_33_23 WL33 BL[23] BLB[23] GND VDD SRAM_CELL
X_cell_33_24 WL33 BL[24] BLB[24] GND VDD SRAM_CELL
X_cell_33_25 WL33 BL[25] BLB[25] GND VDD SRAM_CELL
X_cell_33_26 WL33 BL[26] BLB[26] GND VDD SRAM_CELL
X_cell_33_27 WL33 BL[27] BLB[27] GND VDD SRAM_CELL
X_cell_33_28 WL33 BL[28] BLB[28] GND VDD SRAM_CELL
X_cell_33_29 WL33 BL[29] BLB[29] GND VDD SRAM_CELL
X_cell_33_30 WL33 BL[30] BLB[30] GND VDD SRAM_CELL
X_cell_33_31 WL33 BL[31] BLB[31] GND VDD SRAM_CELL
* Row 34
X_cell_34_0 WL34 BL[0] BLB[0] GND VDD SRAM_CELL
X_cell_34_1 WL34 BL[1] BLB[1] GND VDD SRAM_CELL
X_cell_34_2 WL34 BL[2] BLB[2] GND VDD SRAM_CELL
X_cell_34_3 WL34 BL[3] BLB[3] GND VDD SRAM_CELL
X_cell_34_4 WL34 BL[4] BLB[4] GND VDD SRAM_CELL
X_cell_34_5 WL34 BL[5] BLB[5] GND VDD SRAM_CELL
X_cell_34_6 WL34 BL[6] BLB[6] GND VDD SRAM_CELL
X_cell_34_7 WL34 BL[7] BLB[7] GND VDD SRAM_CELL
X_cell_34_8 WL34 BL[8] BLB[8] GND VDD SRAM_CELL
X_cell_34_9 WL34 BL[9] BLB[9] GND VDD SRAM_CELL
X_cell_34_10 WL34 BL[10] BLB[10] GND VDD SRAM_CELL
X_cell_34_11 WL34 BL[11] BLB[11] GND VDD SRAM_CELL
X_cell_34_12 WL34 BL[12] BLB[12] GND VDD SRAM_CELL
X_cell_34_13 WL34 BL[13] BLB[13] GND VDD SRAM_CELL
X_cell_34_14 WL34 BL[14] BLB[14] GND VDD SRAM_CELL
X_cell_34_15 WL34 BL[15] BLB[15] GND VDD SRAM_CELL
X_cell_34_16 WL34 BL[16] BLB[16] GND VDD SRAM_CELL
X_cell_34_17 WL34 BL[17] BLB[17] GND VDD SRAM_CELL
X_cell_34_18 WL34 BL[18] BLB[18] GND VDD SRAM_CELL
X_cell_34_19 WL34 BL[19] BLB[19] GND VDD SRAM_CELL
X_cell_34_20 WL34 BL[20] BLB[20] GND VDD SRAM_CELL
X_cell_34_21 WL34 BL[21] BLB[21] GND VDD SRAM_CELL
X_cell_34_22 WL34 BL[22] BLB[22] GND VDD SRAM_CELL
X_cell_34_23 WL34 BL[23] BLB[23] GND VDD SRAM_CELL
X_cell_34_24 WL34 BL[24] BLB[24] GND VDD SRAM_CELL
X_cell_34_25 WL34 BL[25] BLB[25] GND VDD SRAM_CELL
X_cell_34_26 WL34 BL[26] BLB[26] GND VDD SRAM_CELL
X_cell_34_27 WL34 BL[27] BLB[27] GND VDD SRAM_CELL
X_cell_34_28 WL34 BL[28] BLB[28] GND VDD SRAM_CELL
X_cell_34_29 WL34 BL[29] BLB[29] GND VDD SRAM_CELL
X_cell_34_30 WL34 BL[30] BLB[30] GND VDD SRAM_CELL
X_cell_34_31 WL34 BL[31] BLB[31] GND VDD SRAM_CELL
* Row 35
X_cell_35_0 WL35 BL[0] BLB[0] GND VDD SRAM_CELL
X_cell_35_1 WL35 BL[1] BLB[1] GND VDD SRAM_CELL
X_cell_35_2 WL35 BL[2] BLB[2] GND VDD SRAM_CELL
X_cell_35_3 WL35 BL[3] BLB[3] GND VDD SRAM_CELL
X_cell_35_4 WL35 BL[4] BLB[4] GND VDD SRAM_CELL
X_cell_35_5 WL35 BL[5] BLB[5] GND VDD SRAM_CELL
X_cell_35_6 WL35 BL[6] BLB[6] GND VDD SRAM_CELL
X_cell_35_7 WL35 BL[7] BLB[7] GND VDD SRAM_CELL
X_cell_35_8 WL35 BL[8] BLB[8] GND VDD SRAM_CELL
X_cell_35_9 WL35 BL[9] BLB[9] GND VDD SRAM_CELL
X_cell_35_10 WL35 BL[10] BLB[10] GND VDD SRAM_CELL
X_cell_35_11 WL35 BL[11] BLB[11] GND VDD SRAM_CELL
X_cell_35_12 WL35 BL[12] BLB[12] GND VDD SRAM_CELL
X_cell_35_13 WL35 BL[13] BLB[13] GND VDD SRAM_CELL
X_cell_35_14 WL35 BL[14] BLB[14] GND VDD SRAM_CELL
X_cell_35_15 WL35 BL[15] BLB[15] GND VDD SRAM_CELL
X_cell_35_16 WL35 BL[16] BLB[16] GND VDD SRAM_CELL
X_cell_35_17 WL35 BL[17] BLB[17] GND VDD SRAM_CELL
X_cell_35_18 WL35 BL[18] BLB[18] GND VDD SRAM_CELL
X_cell_35_19 WL35 BL[19] BLB[19] GND VDD SRAM_CELL
X_cell_35_20 WL35 BL[20] BLB[20] GND VDD SRAM_CELL
X_cell_35_21 WL35 BL[21] BLB[21] GND VDD SRAM_CELL
X_cell_35_22 WL35 BL[22] BLB[22] GND VDD SRAM_CELL
X_cell_35_23 WL35 BL[23] BLB[23] GND VDD SRAM_CELL
X_cell_35_24 WL35 BL[24] BLB[24] GND VDD SRAM_CELL
X_cell_35_25 WL35 BL[25] BLB[25] GND VDD SRAM_CELL
X_cell_35_26 WL35 BL[26] BLB[26] GND VDD SRAM_CELL
X_cell_35_27 WL35 BL[27] BLB[27] GND VDD SRAM_CELL
X_cell_35_28 WL35 BL[28] BLB[28] GND VDD SRAM_CELL
X_cell_35_29 WL35 BL[29] BLB[29] GND VDD SRAM_CELL
X_cell_35_30 WL35 BL[30] BLB[30] GND VDD SRAM_CELL
X_cell_35_31 WL35 BL[31] BLB[31] GND VDD SRAM_CELL
* Row 36
X_cell_36_0 WL36 BL[0] BLB[0] GND VDD SRAM_CELL
X_cell_36_1 WL36 BL[1] BLB[1] GND VDD SRAM_CELL
X_cell_36_2 WL36 BL[2] BLB[2] GND VDD SRAM_CELL
X_cell_36_3 WL36 BL[3] BLB[3] GND VDD SRAM_CELL
X_cell_36_4 WL36 BL[4] BLB[4] GND VDD SRAM_CELL
X_cell_36_5 WL36 BL[5] BLB[5] GND VDD SRAM_CELL
X_cell_36_6 WL36 BL[6] BLB[6] GND VDD SRAM_CELL
X_cell_36_7 WL36 BL[7] BLB[7] GND VDD SRAM_CELL
X_cell_36_8 WL36 BL[8] BLB[8] GND VDD SRAM_CELL
X_cell_36_9 WL36 BL[9] BLB[9] GND VDD SRAM_CELL
X_cell_36_10 WL36 BL[10] BLB[10] GND VDD SRAM_CELL
X_cell_36_11 WL36 BL[11] BLB[11] GND VDD SRAM_CELL
X_cell_36_12 WL36 BL[12] BLB[12] GND VDD SRAM_CELL
X_cell_36_13 WL36 BL[13] BLB[13] GND VDD SRAM_CELL
X_cell_36_14 WL36 BL[14] BLB[14] GND VDD SRAM_CELL
X_cell_36_15 WL36 BL[15] BLB[15] GND VDD SRAM_CELL
X_cell_36_16 WL36 BL[16] BLB[16] GND VDD SRAM_CELL
X_cell_36_17 WL36 BL[17] BLB[17] GND VDD SRAM_CELL
X_cell_36_18 WL36 BL[18] BLB[18] GND VDD SRAM_CELL
X_cell_36_19 WL36 BL[19] BLB[19] GND VDD SRAM_CELL
X_cell_36_20 WL36 BL[20] BLB[20] GND VDD SRAM_CELL
X_cell_36_21 WL36 BL[21] BLB[21] GND VDD SRAM_CELL
X_cell_36_22 WL36 BL[22] BLB[22] GND VDD SRAM_CELL
X_cell_36_23 WL36 BL[23] BLB[23] GND VDD SRAM_CELL
X_cell_36_24 WL36 BL[24] BLB[24] GND VDD SRAM_CELL
X_cell_36_25 WL36 BL[25] BLB[25] GND VDD SRAM_CELL
X_cell_36_26 WL36 BL[26] BLB[26] GND VDD SRAM_CELL
X_cell_36_27 WL36 BL[27] BLB[27] GND VDD SRAM_CELL
X_cell_36_28 WL36 BL[28] BLB[28] GND VDD SRAM_CELL
X_cell_36_29 WL36 BL[29] BLB[29] GND VDD SRAM_CELL
X_cell_36_30 WL36 BL[30] BLB[30] GND VDD SRAM_CELL
X_cell_36_31 WL36 BL[31] BLB[31] GND VDD SRAM_CELL
* Row 37
X_cell_37_0 WL37 BL[0] BLB[0] GND VDD SRAM_CELL
X_cell_37_1 WL37 BL[1] BLB[1] GND VDD SRAM_CELL
X_cell_37_2 WL37 BL[2] BLB[2] GND VDD SRAM_CELL
X_cell_37_3 WL37 BL[3] BLB[3] GND VDD SRAM_CELL
X_cell_37_4 WL37 BL[4] BLB[4] GND VDD SRAM_CELL
X_cell_37_5 WL37 BL[5] BLB[5] GND VDD SRAM_CELL
X_cell_37_6 WL37 BL[6] BLB[6] GND VDD SRAM_CELL
X_cell_37_7 WL37 BL[7] BLB[7] GND VDD SRAM_CELL
X_cell_37_8 WL37 BL[8] BLB[8] GND VDD SRAM_CELL
X_cell_37_9 WL37 BL[9] BLB[9] GND VDD SRAM_CELL
X_cell_37_10 WL37 BL[10] BLB[10] GND VDD SRAM_CELL
X_cell_37_11 WL37 BL[11] BLB[11] GND VDD SRAM_CELL
X_cell_37_12 WL37 BL[12] BLB[12] GND VDD SRAM_CELL
X_cell_37_13 WL37 BL[13] BLB[13] GND VDD SRAM_CELL
X_cell_37_14 WL37 BL[14] BLB[14] GND VDD SRAM_CELL
X_cell_37_15 WL37 BL[15] BLB[15] GND VDD SRAM_CELL
X_cell_37_16 WL37 BL[16] BLB[16] GND VDD SRAM_CELL
X_cell_37_17 WL37 BL[17] BLB[17] GND VDD SRAM_CELL
X_cell_37_18 WL37 BL[18] BLB[18] GND VDD SRAM_CELL
X_cell_37_19 WL37 BL[19] BLB[19] GND VDD SRAM_CELL
X_cell_37_20 WL37 BL[20] BLB[20] GND VDD SRAM_CELL
X_cell_37_21 WL37 BL[21] BLB[21] GND VDD SRAM_CELL
X_cell_37_22 WL37 BL[22] BLB[22] GND VDD SRAM_CELL
X_cell_37_23 WL37 BL[23] BLB[23] GND VDD SRAM_CELL
X_cell_37_24 WL37 BL[24] BLB[24] GND VDD SRAM_CELL
X_cell_37_25 WL37 BL[25] BLB[25] GND VDD SRAM_CELL
X_cell_37_26 WL37 BL[26] BLB[26] GND VDD SRAM_CELL
X_cell_37_27 WL37 BL[27] BLB[27] GND VDD SRAM_CELL
X_cell_37_28 WL37 BL[28] BLB[28] GND VDD SRAM_CELL
X_cell_37_29 WL37 BL[29] BLB[29] GND VDD SRAM_CELL
X_cell_37_30 WL37 BL[30] BLB[30] GND VDD SRAM_CELL
X_cell_37_31 WL37 BL[31] BLB[31] GND VDD SRAM_CELL
* Row 38
X_cell_38_0 WL38 BL[0] BLB[0] GND VDD SRAM_CELL
X_cell_38_1 WL38 BL[1] BLB[1] GND VDD SRAM_CELL
X_cell_38_2 WL38 BL[2] BLB[2] GND VDD SRAM_CELL
X_cell_38_3 WL38 BL[3] BLB[3] GND VDD SRAM_CELL
X_cell_38_4 WL38 BL[4] BLB[4] GND VDD SRAM_CELL
X_cell_38_5 WL38 BL[5] BLB[5] GND VDD SRAM_CELL
X_cell_38_6 WL38 BL[6] BLB[6] GND VDD SRAM_CELL
X_cell_38_7 WL38 BL[7] BLB[7] GND VDD SRAM_CELL
X_cell_38_8 WL38 BL[8] BLB[8] GND VDD SRAM_CELL
X_cell_38_9 WL38 BL[9] BLB[9] GND VDD SRAM_CELL
X_cell_38_10 WL38 BL[10] BLB[10] GND VDD SRAM_CELL
X_cell_38_11 WL38 BL[11] BLB[11] GND VDD SRAM_CELL
X_cell_38_12 WL38 BL[12] BLB[12] GND VDD SRAM_CELL
X_cell_38_13 WL38 BL[13] BLB[13] GND VDD SRAM_CELL
X_cell_38_14 WL38 BL[14] BLB[14] GND VDD SRAM_CELL
X_cell_38_15 WL38 BL[15] BLB[15] GND VDD SRAM_CELL
X_cell_38_16 WL38 BL[16] BLB[16] GND VDD SRAM_CELL
X_cell_38_17 WL38 BL[17] BLB[17] GND VDD SRAM_CELL
X_cell_38_18 WL38 BL[18] BLB[18] GND VDD SRAM_CELL
X_cell_38_19 WL38 BL[19] BLB[19] GND VDD SRAM_CELL
X_cell_38_20 WL38 BL[20] BLB[20] GND VDD SRAM_CELL
X_cell_38_21 WL38 BL[21] BLB[21] GND VDD SRAM_CELL
X_cell_38_22 WL38 BL[22] BLB[22] GND VDD SRAM_CELL
X_cell_38_23 WL38 BL[23] BLB[23] GND VDD SRAM_CELL
X_cell_38_24 WL38 BL[24] BLB[24] GND VDD SRAM_CELL
X_cell_38_25 WL38 BL[25] BLB[25] GND VDD SRAM_CELL
X_cell_38_26 WL38 BL[26] BLB[26] GND VDD SRAM_CELL
X_cell_38_27 WL38 BL[27] BLB[27] GND VDD SRAM_CELL
X_cell_38_28 WL38 BL[28] BLB[28] GND VDD SRAM_CELL
X_cell_38_29 WL38 BL[29] BLB[29] GND VDD SRAM_CELL
X_cell_38_30 WL38 BL[30] BLB[30] GND VDD SRAM_CELL
X_cell_38_31 WL38 BL[31] BLB[31] GND VDD SRAM_CELL
* Row 39
X_cell_39_0 WL39 BL[0] BLB[0] GND VDD SRAM_CELL
X_cell_39_1 WL39 BL[1] BLB[1] GND VDD SRAM_CELL
X_cell_39_2 WL39 BL[2] BLB[2] GND VDD SRAM_CELL
X_cell_39_3 WL39 BL[3] BLB[3] GND VDD SRAM_CELL
X_cell_39_4 WL39 BL[4] BLB[4] GND VDD SRAM_CELL
X_cell_39_5 WL39 BL[5] BLB[5] GND VDD SRAM_CELL
X_cell_39_6 WL39 BL[6] BLB[6] GND VDD SRAM_CELL
X_cell_39_7 WL39 BL[7] BLB[7] GND VDD SRAM_CELL
X_cell_39_8 WL39 BL[8] BLB[8] GND VDD SRAM_CELL
X_cell_39_9 WL39 BL[9] BLB[9] GND VDD SRAM_CELL
X_cell_39_10 WL39 BL[10] BLB[10] GND VDD SRAM_CELL
X_cell_39_11 WL39 BL[11] BLB[11] GND VDD SRAM_CELL
X_cell_39_12 WL39 BL[12] BLB[12] GND VDD SRAM_CELL
X_cell_39_13 WL39 BL[13] BLB[13] GND VDD SRAM_CELL
X_cell_39_14 WL39 BL[14] BLB[14] GND VDD SRAM_CELL
X_cell_39_15 WL39 BL[15] BLB[15] GND VDD SRAM_CELL
X_cell_39_16 WL39 BL[16] BLB[16] GND VDD SRAM_CELL
X_cell_39_17 WL39 BL[17] BLB[17] GND VDD SRAM_CELL
X_cell_39_18 WL39 BL[18] BLB[18] GND VDD SRAM_CELL
X_cell_39_19 WL39 BL[19] BLB[19] GND VDD SRAM_CELL
X_cell_39_20 WL39 BL[20] BLB[20] GND VDD SRAM_CELL
X_cell_39_21 WL39 BL[21] BLB[21] GND VDD SRAM_CELL
X_cell_39_22 WL39 BL[22] BLB[22] GND VDD SRAM_CELL
X_cell_39_23 WL39 BL[23] BLB[23] GND VDD SRAM_CELL
X_cell_39_24 WL39 BL[24] BLB[24] GND VDD SRAM_CELL
X_cell_39_25 WL39 BL[25] BLB[25] GND VDD SRAM_CELL
X_cell_39_26 WL39 BL[26] BLB[26] GND VDD SRAM_CELL
X_cell_39_27 WL39 BL[27] BLB[27] GND VDD SRAM_CELL
X_cell_39_28 WL39 BL[28] BLB[28] GND VDD SRAM_CELL
X_cell_39_29 WL39 BL[29] BLB[29] GND VDD SRAM_CELL
X_cell_39_30 WL39 BL[30] BLB[30] GND VDD SRAM_CELL
X_cell_39_31 WL39 BL[31] BLB[31] GND VDD SRAM_CELL
* Row 40
X_cell_40_0 WL40 BL[0] BLB[0] GND VDD SRAM_CELL
X_cell_40_1 WL40 BL[1] BLB[1] GND VDD SRAM_CELL
X_cell_40_2 WL40 BL[2] BLB[2] GND VDD SRAM_CELL
X_cell_40_3 WL40 BL[3] BLB[3] GND VDD SRAM_CELL
X_cell_40_4 WL40 BL[4] BLB[4] GND VDD SRAM_CELL
X_cell_40_5 WL40 BL[5] BLB[5] GND VDD SRAM_CELL
X_cell_40_6 WL40 BL[6] BLB[6] GND VDD SRAM_CELL
X_cell_40_7 WL40 BL[7] BLB[7] GND VDD SRAM_CELL
X_cell_40_8 WL40 BL[8] BLB[8] GND VDD SRAM_CELL
X_cell_40_9 WL40 BL[9] BLB[9] GND VDD SRAM_CELL
X_cell_40_10 WL40 BL[10] BLB[10] GND VDD SRAM_CELL
X_cell_40_11 WL40 BL[11] BLB[11] GND VDD SRAM_CELL
X_cell_40_12 WL40 BL[12] BLB[12] GND VDD SRAM_CELL
X_cell_40_13 WL40 BL[13] BLB[13] GND VDD SRAM_CELL
X_cell_40_14 WL40 BL[14] BLB[14] GND VDD SRAM_CELL
X_cell_40_15 WL40 BL[15] BLB[15] GND VDD SRAM_CELL
X_cell_40_16 WL40 BL[16] BLB[16] GND VDD SRAM_CELL
X_cell_40_17 WL40 BL[17] BLB[17] GND VDD SRAM_CELL
X_cell_40_18 WL40 BL[18] BLB[18] GND VDD SRAM_CELL
X_cell_40_19 WL40 BL[19] BLB[19] GND VDD SRAM_CELL
X_cell_40_20 WL40 BL[20] BLB[20] GND VDD SRAM_CELL
X_cell_40_21 WL40 BL[21] BLB[21] GND VDD SRAM_CELL
X_cell_40_22 WL40 BL[22] BLB[22] GND VDD SRAM_CELL
X_cell_40_23 WL40 BL[23] BLB[23] GND VDD SRAM_CELL
X_cell_40_24 WL40 BL[24] BLB[24] GND VDD SRAM_CELL
X_cell_40_25 WL40 BL[25] BLB[25] GND VDD SRAM_CELL
X_cell_40_26 WL40 BL[26] BLB[26] GND VDD SRAM_CELL
X_cell_40_27 WL40 BL[27] BLB[27] GND VDD SRAM_CELL
X_cell_40_28 WL40 BL[28] BLB[28] GND VDD SRAM_CELL
X_cell_40_29 WL40 BL[29] BLB[29] GND VDD SRAM_CELL
X_cell_40_30 WL40 BL[30] BLB[30] GND VDD SRAM_CELL
X_cell_40_31 WL40 BL[31] BLB[31] GND VDD SRAM_CELL
* Row 41
X_cell_41_0 WL41 BL[0] BLB[0] GND VDD SRAM_CELL
X_cell_41_1 WL41 BL[1] BLB[1] GND VDD SRAM_CELL
X_cell_41_2 WL41 BL[2] BLB[2] GND VDD SRAM_CELL
X_cell_41_3 WL41 BL[3] BLB[3] GND VDD SRAM_CELL
X_cell_41_4 WL41 BL[4] BLB[4] GND VDD SRAM_CELL
X_cell_41_5 WL41 BL[5] BLB[5] GND VDD SRAM_CELL
X_cell_41_6 WL41 BL[6] BLB[6] GND VDD SRAM_CELL
X_cell_41_7 WL41 BL[7] BLB[7] GND VDD SRAM_CELL
X_cell_41_8 WL41 BL[8] BLB[8] GND VDD SRAM_CELL
X_cell_41_9 WL41 BL[9] BLB[9] GND VDD SRAM_CELL
X_cell_41_10 WL41 BL[10] BLB[10] GND VDD SRAM_CELL
X_cell_41_11 WL41 BL[11] BLB[11] GND VDD SRAM_CELL
X_cell_41_12 WL41 BL[12] BLB[12] GND VDD SRAM_CELL
X_cell_41_13 WL41 BL[13] BLB[13] GND VDD SRAM_CELL
X_cell_41_14 WL41 BL[14] BLB[14] GND VDD SRAM_CELL
X_cell_41_15 WL41 BL[15] BLB[15] GND VDD SRAM_CELL
X_cell_41_16 WL41 BL[16] BLB[16] GND VDD SRAM_CELL
X_cell_41_17 WL41 BL[17] BLB[17] GND VDD SRAM_CELL
X_cell_41_18 WL41 BL[18] BLB[18] GND VDD SRAM_CELL
X_cell_41_19 WL41 BL[19] BLB[19] GND VDD SRAM_CELL
X_cell_41_20 WL41 BL[20] BLB[20] GND VDD SRAM_CELL
X_cell_41_21 WL41 BL[21] BLB[21] GND VDD SRAM_CELL
X_cell_41_22 WL41 BL[22] BLB[22] GND VDD SRAM_CELL
X_cell_41_23 WL41 BL[23] BLB[23] GND VDD SRAM_CELL
X_cell_41_24 WL41 BL[24] BLB[24] GND VDD SRAM_CELL
X_cell_41_25 WL41 BL[25] BLB[25] GND VDD SRAM_CELL
X_cell_41_26 WL41 BL[26] BLB[26] GND VDD SRAM_CELL
X_cell_41_27 WL41 BL[27] BLB[27] GND VDD SRAM_CELL
X_cell_41_28 WL41 BL[28] BLB[28] GND VDD SRAM_CELL
X_cell_41_29 WL41 BL[29] BLB[29] GND VDD SRAM_CELL
X_cell_41_30 WL41 BL[30] BLB[30] GND VDD SRAM_CELL
X_cell_41_31 WL41 BL[31] BLB[31] GND VDD SRAM_CELL
* Row 42
X_cell_42_0 WL42 BL[0] BLB[0] GND VDD SRAM_CELL
X_cell_42_1 WL42 BL[1] BLB[1] GND VDD SRAM_CELL
X_cell_42_2 WL42 BL[2] BLB[2] GND VDD SRAM_CELL
X_cell_42_3 WL42 BL[3] BLB[3] GND VDD SRAM_CELL
X_cell_42_4 WL42 BL[4] BLB[4] GND VDD SRAM_CELL
X_cell_42_5 WL42 BL[5] BLB[5] GND VDD SRAM_CELL
X_cell_42_6 WL42 BL[6] BLB[6] GND VDD SRAM_CELL
X_cell_42_7 WL42 BL[7] BLB[7] GND VDD SRAM_CELL
X_cell_42_8 WL42 BL[8] BLB[8] GND VDD SRAM_CELL
X_cell_42_9 WL42 BL[9] BLB[9] GND VDD SRAM_CELL
X_cell_42_10 WL42 BL[10] BLB[10] GND VDD SRAM_CELL
X_cell_42_11 WL42 BL[11] BLB[11] GND VDD SRAM_CELL
X_cell_42_12 WL42 BL[12] BLB[12] GND VDD SRAM_CELL
X_cell_42_13 WL42 BL[13] BLB[13] GND VDD SRAM_CELL
X_cell_42_14 WL42 BL[14] BLB[14] GND VDD SRAM_CELL
X_cell_42_15 WL42 BL[15] BLB[15] GND VDD SRAM_CELL
X_cell_42_16 WL42 BL[16] BLB[16] GND VDD SRAM_CELL
X_cell_42_17 WL42 BL[17] BLB[17] GND VDD SRAM_CELL
X_cell_42_18 WL42 BL[18] BLB[18] GND VDD SRAM_CELL
X_cell_42_19 WL42 BL[19] BLB[19] GND VDD SRAM_CELL
X_cell_42_20 WL42 BL[20] BLB[20] GND VDD SRAM_CELL
X_cell_42_21 WL42 BL[21] BLB[21] GND VDD SRAM_CELL
X_cell_42_22 WL42 BL[22] BLB[22] GND VDD SRAM_CELL
X_cell_42_23 WL42 BL[23] BLB[23] GND VDD SRAM_CELL
X_cell_42_24 WL42 BL[24] BLB[24] GND VDD SRAM_CELL
X_cell_42_25 WL42 BL[25] BLB[25] GND VDD SRAM_CELL
X_cell_42_26 WL42 BL[26] BLB[26] GND VDD SRAM_CELL
X_cell_42_27 WL42 BL[27] BLB[27] GND VDD SRAM_CELL
X_cell_42_28 WL42 BL[28] BLB[28] GND VDD SRAM_CELL
X_cell_42_29 WL42 BL[29] BLB[29] GND VDD SRAM_CELL
X_cell_42_30 WL42 BL[30] BLB[30] GND VDD SRAM_CELL
X_cell_42_31 WL42 BL[31] BLB[31] GND VDD SRAM_CELL
* Row 43
X_cell_43_0 WL43 BL[0] BLB[0] GND VDD SRAM_CELL
X_cell_43_1 WL43 BL[1] BLB[1] GND VDD SRAM_CELL
X_cell_43_2 WL43 BL[2] BLB[2] GND VDD SRAM_CELL
X_cell_43_3 WL43 BL[3] BLB[3] GND VDD SRAM_CELL
X_cell_43_4 WL43 BL[4] BLB[4] GND VDD SRAM_CELL
X_cell_43_5 WL43 BL[5] BLB[5] GND VDD SRAM_CELL
X_cell_43_6 WL43 BL[6] BLB[6] GND VDD SRAM_CELL
X_cell_43_7 WL43 BL[7] BLB[7] GND VDD SRAM_CELL
X_cell_43_8 WL43 BL[8] BLB[8] GND VDD SRAM_CELL
X_cell_43_9 WL43 BL[9] BLB[9] GND VDD SRAM_CELL
X_cell_43_10 WL43 BL[10] BLB[10] GND VDD SRAM_CELL
X_cell_43_11 WL43 BL[11] BLB[11] GND VDD SRAM_CELL
X_cell_43_12 WL43 BL[12] BLB[12] GND VDD SRAM_CELL
X_cell_43_13 WL43 BL[13] BLB[13] GND VDD SRAM_CELL
X_cell_43_14 WL43 BL[14] BLB[14] GND VDD SRAM_CELL
X_cell_43_15 WL43 BL[15] BLB[15] GND VDD SRAM_CELL
X_cell_43_16 WL43 BL[16] BLB[16] GND VDD SRAM_CELL
X_cell_43_17 WL43 BL[17] BLB[17] GND VDD SRAM_CELL
X_cell_43_18 WL43 BL[18] BLB[18] GND VDD SRAM_CELL
X_cell_43_19 WL43 BL[19] BLB[19] GND VDD SRAM_CELL
X_cell_43_20 WL43 BL[20] BLB[20] GND VDD SRAM_CELL
X_cell_43_21 WL43 BL[21] BLB[21] GND VDD SRAM_CELL
X_cell_43_22 WL43 BL[22] BLB[22] GND VDD SRAM_CELL
X_cell_43_23 WL43 BL[23] BLB[23] GND VDD SRAM_CELL
X_cell_43_24 WL43 BL[24] BLB[24] GND VDD SRAM_CELL
X_cell_43_25 WL43 BL[25] BLB[25] GND VDD SRAM_CELL
X_cell_43_26 WL43 BL[26] BLB[26] GND VDD SRAM_CELL
X_cell_43_27 WL43 BL[27] BLB[27] GND VDD SRAM_CELL
X_cell_43_28 WL43 BL[28] BLB[28] GND VDD SRAM_CELL
X_cell_43_29 WL43 BL[29] BLB[29] GND VDD SRAM_CELL
X_cell_43_30 WL43 BL[30] BLB[30] GND VDD SRAM_CELL
X_cell_43_31 WL43 BL[31] BLB[31] GND VDD SRAM_CELL
* Row 44
X_cell_44_0 WL44 BL[0] BLB[0] GND VDD SRAM_CELL
X_cell_44_1 WL44 BL[1] BLB[1] GND VDD SRAM_CELL
X_cell_44_2 WL44 BL[2] BLB[2] GND VDD SRAM_CELL
X_cell_44_3 WL44 BL[3] BLB[3] GND VDD SRAM_CELL
X_cell_44_4 WL44 BL[4] BLB[4] GND VDD SRAM_CELL
X_cell_44_5 WL44 BL[5] BLB[5] GND VDD SRAM_CELL
X_cell_44_6 WL44 BL[6] BLB[6] GND VDD SRAM_CELL
X_cell_44_7 WL44 BL[7] BLB[7] GND VDD SRAM_CELL
X_cell_44_8 WL44 BL[8] BLB[8] GND VDD SRAM_CELL
X_cell_44_9 WL44 BL[9] BLB[9] GND VDD SRAM_CELL
X_cell_44_10 WL44 BL[10] BLB[10] GND VDD SRAM_CELL
X_cell_44_11 WL44 BL[11] BLB[11] GND VDD SRAM_CELL
X_cell_44_12 WL44 BL[12] BLB[12] GND VDD SRAM_CELL
X_cell_44_13 WL44 BL[13] BLB[13] GND VDD SRAM_CELL
X_cell_44_14 WL44 BL[14] BLB[14] GND VDD SRAM_CELL
X_cell_44_15 WL44 BL[15] BLB[15] GND VDD SRAM_CELL
X_cell_44_16 WL44 BL[16] BLB[16] GND VDD SRAM_CELL
X_cell_44_17 WL44 BL[17] BLB[17] GND VDD SRAM_CELL
X_cell_44_18 WL44 BL[18] BLB[18] GND VDD SRAM_CELL
X_cell_44_19 WL44 BL[19] BLB[19] GND VDD SRAM_CELL
X_cell_44_20 WL44 BL[20] BLB[20] GND VDD SRAM_CELL
X_cell_44_21 WL44 BL[21] BLB[21] GND VDD SRAM_CELL
X_cell_44_22 WL44 BL[22] BLB[22] GND VDD SRAM_CELL
X_cell_44_23 WL44 BL[23] BLB[23] GND VDD SRAM_CELL
X_cell_44_24 WL44 BL[24] BLB[24] GND VDD SRAM_CELL
X_cell_44_25 WL44 BL[25] BLB[25] GND VDD SRAM_CELL
X_cell_44_26 WL44 BL[26] BLB[26] GND VDD SRAM_CELL
X_cell_44_27 WL44 BL[27] BLB[27] GND VDD SRAM_CELL
X_cell_44_28 WL44 BL[28] BLB[28] GND VDD SRAM_CELL
X_cell_44_29 WL44 BL[29] BLB[29] GND VDD SRAM_CELL
X_cell_44_30 WL44 BL[30] BLB[30] GND VDD SRAM_CELL
X_cell_44_31 WL44 BL[31] BLB[31] GND VDD SRAM_CELL
* Row 45
X_cell_45_0 WL45 BL[0] BLB[0] GND VDD SRAM_CELL
X_cell_45_1 WL45 BL[1] BLB[1] GND VDD SRAM_CELL
X_cell_45_2 WL45 BL[2] BLB[2] GND VDD SRAM_CELL
X_cell_45_3 WL45 BL[3] BLB[3] GND VDD SRAM_CELL
X_cell_45_4 WL45 BL[4] BLB[4] GND VDD SRAM_CELL
X_cell_45_5 WL45 BL[5] BLB[5] GND VDD SRAM_CELL
X_cell_45_6 WL45 BL[6] BLB[6] GND VDD SRAM_CELL
X_cell_45_7 WL45 BL[7] BLB[7] GND VDD SRAM_CELL
X_cell_45_8 WL45 BL[8] BLB[8] GND VDD SRAM_CELL
X_cell_45_9 WL45 BL[9] BLB[9] GND VDD SRAM_CELL
X_cell_45_10 WL45 BL[10] BLB[10] GND VDD SRAM_CELL
X_cell_45_11 WL45 BL[11] BLB[11] GND VDD SRAM_CELL
X_cell_45_12 WL45 BL[12] BLB[12] GND VDD SRAM_CELL
X_cell_45_13 WL45 BL[13] BLB[13] GND VDD SRAM_CELL
X_cell_45_14 WL45 BL[14] BLB[14] GND VDD SRAM_CELL
X_cell_45_15 WL45 BL[15] BLB[15] GND VDD SRAM_CELL
X_cell_45_16 WL45 BL[16] BLB[16] GND VDD SRAM_CELL
X_cell_45_17 WL45 BL[17] BLB[17] GND VDD SRAM_CELL
X_cell_45_18 WL45 BL[18] BLB[18] GND VDD SRAM_CELL
X_cell_45_19 WL45 BL[19] BLB[19] GND VDD SRAM_CELL
X_cell_45_20 WL45 BL[20] BLB[20] GND VDD SRAM_CELL
X_cell_45_21 WL45 BL[21] BLB[21] GND VDD SRAM_CELL
X_cell_45_22 WL45 BL[22] BLB[22] GND VDD SRAM_CELL
X_cell_45_23 WL45 BL[23] BLB[23] GND VDD SRAM_CELL
X_cell_45_24 WL45 BL[24] BLB[24] GND VDD SRAM_CELL
X_cell_45_25 WL45 BL[25] BLB[25] GND VDD SRAM_CELL
X_cell_45_26 WL45 BL[26] BLB[26] GND VDD SRAM_CELL
X_cell_45_27 WL45 BL[27] BLB[27] GND VDD SRAM_CELL
X_cell_45_28 WL45 BL[28] BLB[28] GND VDD SRAM_CELL
X_cell_45_29 WL45 BL[29] BLB[29] GND VDD SRAM_CELL
X_cell_45_30 WL45 BL[30] BLB[30] GND VDD SRAM_CELL
X_cell_45_31 WL45 BL[31] BLB[31] GND VDD SRAM_CELL
* Row 46
X_cell_46_0 WL46 BL[0] BLB[0] GND VDD SRAM_CELL
X_cell_46_1 WL46 BL[1] BLB[1] GND VDD SRAM_CELL
X_cell_46_2 WL46 BL[2] BLB[2] GND VDD SRAM_CELL
X_cell_46_3 WL46 BL[3] BLB[3] GND VDD SRAM_CELL
X_cell_46_4 WL46 BL[4] BLB[4] GND VDD SRAM_CELL
X_cell_46_5 WL46 BL[5] BLB[5] GND VDD SRAM_CELL
X_cell_46_6 WL46 BL[6] BLB[6] GND VDD SRAM_CELL
X_cell_46_7 WL46 BL[7] BLB[7] GND VDD SRAM_CELL
X_cell_46_8 WL46 BL[8] BLB[8] GND VDD SRAM_CELL
X_cell_46_9 WL46 BL[9] BLB[9] GND VDD SRAM_CELL
X_cell_46_10 WL46 BL[10] BLB[10] GND VDD SRAM_CELL
X_cell_46_11 WL46 BL[11] BLB[11] GND VDD SRAM_CELL
X_cell_46_12 WL46 BL[12] BLB[12] GND VDD SRAM_CELL
X_cell_46_13 WL46 BL[13] BLB[13] GND VDD SRAM_CELL
X_cell_46_14 WL46 BL[14] BLB[14] GND VDD SRAM_CELL
X_cell_46_15 WL46 BL[15] BLB[15] GND VDD SRAM_CELL
X_cell_46_16 WL46 BL[16] BLB[16] GND VDD SRAM_CELL
X_cell_46_17 WL46 BL[17] BLB[17] GND VDD SRAM_CELL
X_cell_46_18 WL46 BL[18] BLB[18] GND VDD SRAM_CELL
X_cell_46_19 WL46 BL[19] BLB[19] GND VDD SRAM_CELL
X_cell_46_20 WL46 BL[20] BLB[20] GND VDD SRAM_CELL
X_cell_46_21 WL46 BL[21] BLB[21] GND VDD SRAM_CELL
X_cell_46_22 WL46 BL[22] BLB[22] GND VDD SRAM_CELL
X_cell_46_23 WL46 BL[23] BLB[23] GND VDD SRAM_CELL
X_cell_46_24 WL46 BL[24] BLB[24] GND VDD SRAM_CELL
X_cell_46_25 WL46 BL[25] BLB[25] GND VDD SRAM_CELL
X_cell_46_26 WL46 BL[26] BLB[26] GND VDD SRAM_CELL
X_cell_46_27 WL46 BL[27] BLB[27] GND VDD SRAM_CELL
X_cell_46_28 WL46 BL[28] BLB[28] GND VDD SRAM_CELL
X_cell_46_29 WL46 BL[29] BLB[29] GND VDD SRAM_CELL
X_cell_46_30 WL46 BL[30] BLB[30] GND VDD SRAM_CELL
X_cell_46_31 WL46 BL[31] BLB[31] GND VDD SRAM_CELL
* Row 47
X_cell_47_0 WL47 BL[0] BLB[0] GND VDD SRAM_CELL
X_cell_47_1 WL47 BL[1] BLB[1] GND VDD SRAM_CELL
X_cell_47_2 WL47 BL[2] BLB[2] GND VDD SRAM_CELL
X_cell_47_3 WL47 BL[3] BLB[3] GND VDD SRAM_CELL
X_cell_47_4 WL47 BL[4] BLB[4] GND VDD SRAM_CELL
X_cell_47_5 WL47 BL[5] BLB[5] GND VDD SRAM_CELL
X_cell_47_6 WL47 BL[6] BLB[6] GND VDD SRAM_CELL
X_cell_47_7 WL47 BL[7] BLB[7] GND VDD SRAM_CELL
X_cell_47_8 WL47 BL[8] BLB[8] GND VDD SRAM_CELL
X_cell_47_9 WL47 BL[9] BLB[9] GND VDD SRAM_CELL
X_cell_47_10 WL47 BL[10] BLB[10] GND VDD SRAM_CELL
X_cell_47_11 WL47 BL[11] BLB[11] GND VDD SRAM_CELL
X_cell_47_12 WL47 BL[12] BLB[12] GND VDD SRAM_CELL
X_cell_47_13 WL47 BL[13] BLB[13] GND VDD SRAM_CELL
X_cell_47_14 WL47 BL[14] BLB[14] GND VDD SRAM_CELL
X_cell_47_15 WL47 BL[15] BLB[15] GND VDD SRAM_CELL
X_cell_47_16 WL47 BL[16] BLB[16] GND VDD SRAM_CELL
X_cell_47_17 WL47 BL[17] BLB[17] GND VDD SRAM_CELL
X_cell_47_18 WL47 BL[18] BLB[18] GND VDD SRAM_CELL
X_cell_47_19 WL47 BL[19] BLB[19] GND VDD SRAM_CELL
X_cell_47_20 WL47 BL[20] BLB[20] GND VDD SRAM_CELL
X_cell_47_21 WL47 BL[21] BLB[21] GND VDD SRAM_CELL
X_cell_47_22 WL47 BL[22] BLB[22] GND VDD SRAM_CELL
X_cell_47_23 WL47 BL[23] BLB[23] GND VDD SRAM_CELL
X_cell_47_24 WL47 BL[24] BLB[24] GND VDD SRAM_CELL
X_cell_47_25 WL47 BL[25] BLB[25] GND VDD SRAM_CELL
X_cell_47_26 WL47 BL[26] BLB[26] GND VDD SRAM_CELL
X_cell_47_27 WL47 BL[27] BLB[27] GND VDD SRAM_CELL
X_cell_47_28 WL47 BL[28] BLB[28] GND VDD SRAM_CELL
X_cell_47_29 WL47 BL[29] BLB[29] GND VDD SRAM_CELL
X_cell_47_30 WL47 BL[30] BLB[30] GND VDD SRAM_CELL
X_cell_47_31 WL47 BL[31] BLB[31] GND VDD SRAM_CELL
* Row 48
X_cell_48_0 WL48 BL[0] BLB[0] GND VDD SRAM_CELL
X_cell_48_1 WL48 BL[1] BLB[1] GND VDD SRAM_CELL
X_cell_48_2 WL48 BL[2] BLB[2] GND VDD SRAM_CELL
X_cell_48_3 WL48 BL[3] BLB[3] GND VDD SRAM_CELL
X_cell_48_4 WL48 BL[4] BLB[4] GND VDD SRAM_CELL
X_cell_48_5 WL48 BL[5] BLB[5] GND VDD SRAM_CELL
X_cell_48_6 WL48 BL[6] BLB[6] GND VDD SRAM_CELL
X_cell_48_7 WL48 BL[7] BLB[7] GND VDD SRAM_CELL
X_cell_48_8 WL48 BL[8] BLB[8] GND VDD SRAM_CELL
X_cell_48_9 WL48 BL[9] BLB[9] GND VDD SRAM_CELL
X_cell_48_10 WL48 BL[10] BLB[10] GND VDD SRAM_CELL
X_cell_48_11 WL48 BL[11] BLB[11] GND VDD SRAM_CELL
X_cell_48_12 WL48 BL[12] BLB[12] GND VDD SRAM_CELL
X_cell_48_13 WL48 BL[13] BLB[13] GND VDD SRAM_CELL
X_cell_48_14 WL48 BL[14] BLB[14] GND VDD SRAM_CELL
X_cell_48_15 WL48 BL[15] BLB[15] GND VDD SRAM_CELL
X_cell_48_16 WL48 BL[16] BLB[16] GND VDD SRAM_CELL
X_cell_48_17 WL48 BL[17] BLB[17] GND VDD SRAM_CELL
X_cell_48_18 WL48 BL[18] BLB[18] GND VDD SRAM_CELL
X_cell_48_19 WL48 BL[19] BLB[19] GND VDD SRAM_CELL
X_cell_48_20 WL48 BL[20] BLB[20] GND VDD SRAM_CELL
X_cell_48_21 WL48 BL[21] BLB[21] GND VDD SRAM_CELL
X_cell_48_22 WL48 BL[22] BLB[22] GND VDD SRAM_CELL
X_cell_48_23 WL48 BL[23] BLB[23] GND VDD SRAM_CELL
X_cell_48_24 WL48 BL[24] BLB[24] GND VDD SRAM_CELL
X_cell_48_25 WL48 BL[25] BLB[25] GND VDD SRAM_CELL
X_cell_48_26 WL48 BL[26] BLB[26] GND VDD SRAM_CELL
X_cell_48_27 WL48 BL[27] BLB[27] GND VDD SRAM_CELL
X_cell_48_28 WL48 BL[28] BLB[28] GND VDD SRAM_CELL
X_cell_48_29 WL48 BL[29] BLB[29] GND VDD SRAM_CELL
X_cell_48_30 WL48 BL[30] BLB[30] GND VDD SRAM_CELL
X_cell_48_31 WL48 BL[31] BLB[31] GND VDD SRAM_CELL
* Row 49
X_cell_49_0 WL49 BL[0] BLB[0] GND VDD SRAM_CELL
X_cell_49_1 WL49 BL[1] BLB[1] GND VDD SRAM_CELL
X_cell_49_2 WL49 BL[2] BLB[2] GND VDD SRAM_CELL
X_cell_49_3 WL49 BL[3] BLB[3] GND VDD SRAM_CELL
X_cell_49_4 WL49 BL[4] BLB[4] GND VDD SRAM_CELL
X_cell_49_5 WL49 BL[5] BLB[5] GND VDD SRAM_CELL
X_cell_49_6 WL49 BL[6] BLB[6] GND VDD SRAM_CELL
X_cell_49_7 WL49 BL[7] BLB[7] GND VDD SRAM_CELL
X_cell_49_8 WL49 BL[8] BLB[8] GND VDD SRAM_CELL
X_cell_49_9 WL49 BL[9] BLB[9] GND VDD SRAM_CELL
X_cell_49_10 WL49 BL[10] BLB[10] GND VDD SRAM_CELL
X_cell_49_11 WL49 BL[11] BLB[11] GND VDD SRAM_CELL
X_cell_49_12 WL49 BL[12] BLB[12] GND VDD SRAM_CELL
X_cell_49_13 WL49 BL[13] BLB[13] GND VDD SRAM_CELL
X_cell_49_14 WL49 BL[14] BLB[14] GND VDD SRAM_CELL
X_cell_49_15 WL49 BL[15] BLB[15] GND VDD SRAM_CELL
X_cell_49_16 WL49 BL[16] BLB[16] GND VDD SRAM_CELL
X_cell_49_17 WL49 BL[17] BLB[17] GND VDD SRAM_CELL
X_cell_49_18 WL49 BL[18] BLB[18] GND VDD SRAM_CELL
X_cell_49_19 WL49 BL[19] BLB[19] GND VDD SRAM_CELL
X_cell_49_20 WL49 BL[20] BLB[20] GND VDD SRAM_CELL
X_cell_49_21 WL49 BL[21] BLB[21] GND VDD SRAM_CELL
X_cell_49_22 WL49 BL[22] BLB[22] GND VDD SRAM_CELL
X_cell_49_23 WL49 BL[23] BLB[23] GND VDD SRAM_CELL
X_cell_49_24 WL49 BL[24] BLB[24] GND VDD SRAM_CELL
X_cell_49_25 WL49 BL[25] BLB[25] GND VDD SRAM_CELL
X_cell_49_26 WL49 BL[26] BLB[26] GND VDD SRAM_CELL
X_cell_49_27 WL49 BL[27] BLB[27] GND VDD SRAM_CELL
X_cell_49_28 WL49 BL[28] BLB[28] GND VDD SRAM_CELL
X_cell_49_29 WL49 BL[29] BLB[29] GND VDD SRAM_CELL
X_cell_49_30 WL49 BL[30] BLB[30] GND VDD SRAM_CELL
X_cell_49_31 WL49 BL[31] BLB[31] GND VDD SRAM_CELL
* Row 50
X_cell_50_0 WL50 BL[0] BLB[0] GND VDD SRAM_CELL
X_cell_50_1 WL50 BL[1] BLB[1] GND VDD SRAM_CELL
X_cell_50_2 WL50 BL[2] BLB[2] GND VDD SRAM_CELL
X_cell_50_3 WL50 BL[3] BLB[3] GND VDD SRAM_CELL
X_cell_50_4 WL50 BL[4] BLB[4] GND VDD SRAM_CELL
X_cell_50_5 WL50 BL[5] BLB[5] GND VDD SRAM_CELL
X_cell_50_6 WL50 BL[6] BLB[6] GND VDD SRAM_CELL
X_cell_50_7 WL50 BL[7] BLB[7] GND VDD SRAM_CELL
X_cell_50_8 WL50 BL[8] BLB[8] GND VDD SRAM_CELL
X_cell_50_9 WL50 BL[9] BLB[9] GND VDD SRAM_CELL
X_cell_50_10 WL50 BL[10] BLB[10] GND VDD SRAM_CELL
X_cell_50_11 WL50 BL[11] BLB[11] GND VDD SRAM_CELL
X_cell_50_12 WL50 BL[12] BLB[12] GND VDD SRAM_CELL
X_cell_50_13 WL50 BL[13] BLB[13] GND VDD SRAM_CELL
X_cell_50_14 WL50 BL[14] BLB[14] GND VDD SRAM_CELL
X_cell_50_15 WL50 BL[15] BLB[15] GND VDD SRAM_CELL
X_cell_50_16 WL50 BL[16] BLB[16] GND VDD SRAM_CELL
X_cell_50_17 WL50 BL[17] BLB[17] GND VDD SRAM_CELL
X_cell_50_18 WL50 BL[18] BLB[18] GND VDD SRAM_CELL
X_cell_50_19 WL50 BL[19] BLB[19] GND VDD SRAM_CELL
X_cell_50_20 WL50 BL[20] BLB[20] GND VDD SRAM_CELL
X_cell_50_21 WL50 BL[21] BLB[21] GND VDD SRAM_CELL
X_cell_50_22 WL50 BL[22] BLB[22] GND VDD SRAM_CELL
X_cell_50_23 WL50 BL[23] BLB[23] GND VDD SRAM_CELL
X_cell_50_24 WL50 BL[24] BLB[24] GND VDD SRAM_CELL
X_cell_50_25 WL50 BL[25] BLB[25] GND VDD SRAM_CELL
X_cell_50_26 WL50 BL[26] BLB[26] GND VDD SRAM_CELL
X_cell_50_27 WL50 BL[27] BLB[27] GND VDD SRAM_CELL
X_cell_50_28 WL50 BL[28] BLB[28] GND VDD SRAM_CELL
X_cell_50_29 WL50 BL[29] BLB[29] GND VDD SRAM_CELL
X_cell_50_30 WL50 BL[30] BLB[30] GND VDD SRAM_CELL
X_cell_50_31 WL50 BL[31] BLB[31] GND VDD SRAM_CELL
* Row 51
X_cell_51_0 WL51 BL[0] BLB[0] GND VDD SRAM_CELL
X_cell_51_1 WL51 BL[1] BLB[1] GND VDD SRAM_CELL
X_cell_51_2 WL51 BL[2] BLB[2] GND VDD SRAM_CELL
X_cell_51_3 WL51 BL[3] BLB[3] GND VDD SRAM_CELL
X_cell_51_4 WL51 BL[4] BLB[4] GND VDD SRAM_CELL
X_cell_51_5 WL51 BL[5] BLB[5] GND VDD SRAM_CELL
X_cell_51_6 WL51 BL[6] BLB[6] GND VDD SRAM_CELL
X_cell_51_7 WL51 BL[7] BLB[7] GND VDD SRAM_CELL
X_cell_51_8 WL51 BL[8] BLB[8] GND VDD SRAM_CELL
X_cell_51_9 WL51 BL[9] BLB[9] GND VDD SRAM_CELL
X_cell_51_10 WL51 BL[10] BLB[10] GND VDD SRAM_CELL
X_cell_51_11 WL51 BL[11] BLB[11] GND VDD SRAM_CELL
X_cell_51_12 WL51 BL[12] BLB[12] GND VDD SRAM_CELL
X_cell_51_13 WL51 BL[13] BLB[13] GND VDD SRAM_CELL
X_cell_51_14 WL51 BL[14] BLB[14] GND VDD SRAM_CELL
X_cell_51_15 WL51 BL[15] BLB[15] GND VDD SRAM_CELL
X_cell_51_16 WL51 BL[16] BLB[16] GND VDD SRAM_CELL
X_cell_51_17 WL51 BL[17] BLB[17] GND VDD SRAM_CELL
X_cell_51_18 WL51 BL[18] BLB[18] GND VDD SRAM_CELL
X_cell_51_19 WL51 BL[19] BLB[19] GND VDD SRAM_CELL
X_cell_51_20 WL51 BL[20] BLB[20] GND VDD SRAM_CELL
X_cell_51_21 WL51 BL[21] BLB[21] GND VDD SRAM_CELL
X_cell_51_22 WL51 BL[22] BLB[22] GND VDD SRAM_CELL
X_cell_51_23 WL51 BL[23] BLB[23] GND VDD SRAM_CELL
X_cell_51_24 WL51 BL[24] BLB[24] GND VDD SRAM_CELL
X_cell_51_25 WL51 BL[25] BLB[25] GND VDD SRAM_CELL
X_cell_51_26 WL51 BL[26] BLB[26] GND VDD SRAM_CELL
X_cell_51_27 WL51 BL[27] BLB[27] GND VDD SRAM_CELL
X_cell_51_28 WL51 BL[28] BLB[28] GND VDD SRAM_CELL
X_cell_51_29 WL51 BL[29] BLB[29] GND VDD SRAM_CELL
X_cell_51_30 WL51 BL[30] BLB[30] GND VDD SRAM_CELL
X_cell_51_31 WL51 BL[31] BLB[31] GND VDD SRAM_CELL
* Row 52
X_cell_52_0 WL52 BL[0] BLB[0] GND VDD SRAM_CELL
X_cell_52_1 WL52 BL[1] BLB[1] GND VDD SRAM_CELL
X_cell_52_2 WL52 BL[2] BLB[2] GND VDD SRAM_CELL
X_cell_52_3 WL52 BL[3] BLB[3] GND VDD SRAM_CELL
X_cell_52_4 WL52 BL[4] BLB[4] GND VDD SRAM_CELL
X_cell_52_5 WL52 BL[5] BLB[5] GND VDD SRAM_CELL
X_cell_52_6 WL52 BL[6] BLB[6] GND VDD SRAM_CELL
X_cell_52_7 WL52 BL[7] BLB[7] GND VDD SRAM_CELL
X_cell_52_8 WL52 BL[8] BLB[8] GND VDD SRAM_CELL
X_cell_52_9 WL52 BL[9] BLB[9] GND VDD SRAM_CELL
X_cell_52_10 WL52 BL[10] BLB[10] GND VDD SRAM_CELL
X_cell_52_11 WL52 BL[11] BLB[11] GND VDD SRAM_CELL
X_cell_52_12 WL52 BL[12] BLB[12] GND VDD SRAM_CELL
X_cell_52_13 WL52 BL[13] BLB[13] GND VDD SRAM_CELL
X_cell_52_14 WL52 BL[14] BLB[14] GND VDD SRAM_CELL
X_cell_52_15 WL52 BL[15] BLB[15] GND VDD SRAM_CELL
X_cell_52_16 WL52 BL[16] BLB[16] GND VDD SRAM_CELL
X_cell_52_17 WL52 BL[17] BLB[17] GND VDD SRAM_CELL
X_cell_52_18 WL52 BL[18] BLB[18] GND VDD SRAM_CELL
X_cell_52_19 WL52 BL[19] BLB[19] GND VDD SRAM_CELL
X_cell_52_20 WL52 BL[20] BLB[20] GND VDD SRAM_CELL
X_cell_52_21 WL52 BL[21] BLB[21] GND VDD SRAM_CELL
X_cell_52_22 WL52 BL[22] BLB[22] GND VDD SRAM_CELL
X_cell_52_23 WL52 BL[23] BLB[23] GND VDD SRAM_CELL
X_cell_52_24 WL52 BL[24] BLB[24] GND VDD SRAM_CELL
X_cell_52_25 WL52 BL[25] BLB[25] GND VDD SRAM_CELL
X_cell_52_26 WL52 BL[26] BLB[26] GND VDD SRAM_CELL
X_cell_52_27 WL52 BL[27] BLB[27] GND VDD SRAM_CELL
X_cell_52_28 WL52 BL[28] BLB[28] GND VDD SRAM_CELL
X_cell_52_29 WL52 BL[29] BLB[29] GND VDD SRAM_CELL
X_cell_52_30 WL52 BL[30] BLB[30] GND VDD SRAM_CELL
X_cell_52_31 WL52 BL[31] BLB[31] GND VDD SRAM_CELL
* Row 53
X_cell_53_0 WL53 BL[0] BLB[0] GND VDD SRAM_CELL
X_cell_53_1 WL53 BL[1] BLB[1] GND VDD SRAM_CELL
X_cell_53_2 WL53 BL[2] BLB[2] GND VDD SRAM_CELL
X_cell_53_3 WL53 BL[3] BLB[3] GND VDD SRAM_CELL
X_cell_53_4 WL53 BL[4] BLB[4] GND VDD SRAM_CELL
X_cell_53_5 WL53 BL[5] BLB[5] GND VDD SRAM_CELL
X_cell_53_6 WL53 BL[6] BLB[6] GND VDD SRAM_CELL
X_cell_53_7 WL53 BL[7] BLB[7] GND VDD SRAM_CELL
X_cell_53_8 WL53 BL[8] BLB[8] GND VDD SRAM_CELL
X_cell_53_9 WL53 BL[9] BLB[9] GND VDD SRAM_CELL
X_cell_53_10 WL53 BL[10] BLB[10] GND VDD SRAM_CELL
X_cell_53_11 WL53 BL[11] BLB[11] GND VDD SRAM_CELL
X_cell_53_12 WL53 BL[12] BLB[12] GND VDD SRAM_CELL
X_cell_53_13 WL53 BL[13] BLB[13] GND VDD SRAM_CELL
X_cell_53_14 WL53 BL[14] BLB[14] GND VDD SRAM_CELL
X_cell_53_15 WL53 BL[15] BLB[15] GND VDD SRAM_CELL
X_cell_53_16 WL53 BL[16] BLB[16] GND VDD SRAM_CELL
X_cell_53_17 WL53 BL[17] BLB[17] GND VDD SRAM_CELL
X_cell_53_18 WL53 BL[18] BLB[18] GND VDD SRAM_CELL
X_cell_53_19 WL53 BL[19] BLB[19] GND VDD SRAM_CELL
X_cell_53_20 WL53 BL[20] BLB[20] GND VDD SRAM_CELL
X_cell_53_21 WL53 BL[21] BLB[21] GND VDD SRAM_CELL
X_cell_53_22 WL53 BL[22] BLB[22] GND VDD SRAM_CELL
X_cell_53_23 WL53 BL[23] BLB[23] GND VDD SRAM_CELL
X_cell_53_24 WL53 BL[24] BLB[24] GND VDD SRAM_CELL
X_cell_53_25 WL53 BL[25] BLB[25] GND VDD SRAM_CELL
X_cell_53_26 WL53 BL[26] BLB[26] GND VDD SRAM_CELL
X_cell_53_27 WL53 BL[27] BLB[27] GND VDD SRAM_CELL
X_cell_53_28 WL53 BL[28] BLB[28] GND VDD SRAM_CELL
X_cell_53_29 WL53 BL[29] BLB[29] GND VDD SRAM_CELL
X_cell_53_30 WL53 BL[30] BLB[30] GND VDD SRAM_CELL
X_cell_53_31 WL53 BL[31] BLB[31] GND VDD SRAM_CELL
* Row 54
X_cell_54_0 WL54 BL[0] BLB[0] GND VDD SRAM_CELL
X_cell_54_1 WL54 BL[1] BLB[1] GND VDD SRAM_CELL
X_cell_54_2 WL54 BL[2] BLB[2] GND VDD SRAM_CELL
X_cell_54_3 WL54 BL[3] BLB[3] GND VDD SRAM_CELL
X_cell_54_4 WL54 BL[4] BLB[4] GND VDD SRAM_CELL
X_cell_54_5 WL54 BL[5] BLB[5] GND VDD SRAM_CELL
X_cell_54_6 WL54 BL[6] BLB[6] GND VDD SRAM_CELL
X_cell_54_7 WL54 BL[7] BLB[7] GND VDD SRAM_CELL
X_cell_54_8 WL54 BL[8] BLB[8] GND VDD SRAM_CELL
X_cell_54_9 WL54 BL[9] BLB[9] GND VDD SRAM_CELL
X_cell_54_10 WL54 BL[10] BLB[10] GND VDD SRAM_CELL
X_cell_54_11 WL54 BL[11] BLB[11] GND VDD SRAM_CELL
X_cell_54_12 WL54 BL[12] BLB[12] GND VDD SRAM_CELL
X_cell_54_13 WL54 BL[13] BLB[13] GND VDD SRAM_CELL
X_cell_54_14 WL54 BL[14] BLB[14] GND VDD SRAM_CELL
X_cell_54_15 WL54 BL[15] BLB[15] GND VDD SRAM_CELL
X_cell_54_16 WL54 BL[16] BLB[16] GND VDD SRAM_CELL
X_cell_54_17 WL54 BL[17] BLB[17] GND VDD SRAM_CELL
X_cell_54_18 WL54 BL[18] BLB[18] GND VDD SRAM_CELL
X_cell_54_19 WL54 BL[19] BLB[19] GND VDD SRAM_CELL
X_cell_54_20 WL54 BL[20] BLB[20] GND VDD SRAM_CELL
X_cell_54_21 WL54 BL[21] BLB[21] GND VDD SRAM_CELL
X_cell_54_22 WL54 BL[22] BLB[22] GND VDD SRAM_CELL
X_cell_54_23 WL54 BL[23] BLB[23] GND VDD SRAM_CELL
X_cell_54_24 WL54 BL[24] BLB[24] GND VDD SRAM_CELL
X_cell_54_25 WL54 BL[25] BLB[25] GND VDD SRAM_CELL
X_cell_54_26 WL54 BL[26] BLB[26] GND VDD SRAM_CELL
X_cell_54_27 WL54 BL[27] BLB[27] GND VDD SRAM_CELL
X_cell_54_28 WL54 BL[28] BLB[28] GND VDD SRAM_CELL
X_cell_54_29 WL54 BL[29] BLB[29] GND VDD SRAM_CELL
X_cell_54_30 WL54 BL[30] BLB[30] GND VDD SRAM_CELL
X_cell_54_31 WL54 BL[31] BLB[31] GND VDD SRAM_CELL
* Row 55
X_cell_55_0 WL55 BL[0] BLB[0] GND VDD SRAM_CELL
X_cell_55_1 WL55 BL[1] BLB[1] GND VDD SRAM_CELL
X_cell_55_2 WL55 BL[2] BLB[2] GND VDD SRAM_CELL
X_cell_55_3 WL55 BL[3] BLB[3] GND VDD SRAM_CELL
X_cell_55_4 WL55 BL[4] BLB[4] GND VDD SRAM_CELL
X_cell_55_5 WL55 BL[5] BLB[5] GND VDD SRAM_CELL
X_cell_55_6 WL55 BL[6] BLB[6] GND VDD SRAM_CELL
X_cell_55_7 WL55 BL[7] BLB[7] GND VDD SRAM_CELL
X_cell_55_8 WL55 BL[8] BLB[8] GND VDD SRAM_CELL
X_cell_55_9 WL55 BL[9] BLB[9] GND VDD SRAM_CELL
X_cell_55_10 WL55 BL[10] BLB[10] GND VDD SRAM_CELL
X_cell_55_11 WL55 BL[11] BLB[11] GND VDD SRAM_CELL
X_cell_55_12 WL55 BL[12] BLB[12] GND VDD SRAM_CELL
X_cell_55_13 WL55 BL[13] BLB[13] GND VDD SRAM_CELL
X_cell_55_14 WL55 BL[14] BLB[14] GND VDD SRAM_CELL
X_cell_55_15 WL55 BL[15] BLB[15] GND VDD SRAM_CELL
X_cell_55_16 WL55 BL[16] BLB[16] GND VDD SRAM_CELL
X_cell_55_17 WL55 BL[17] BLB[17] GND VDD SRAM_CELL
X_cell_55_18 WL55 BL[18] BLB[18] GND VDD SRAM_CELL
X_cell_55_19 WL55 BL[19] BLB[19] GND VDD SRAM_CELL
X_cell_55_20 WL55 BL[20] BLB[20] GND VDD SRAM_CELL
X_cell_55_21 WL55 BL[21] BLB[21] GND VDD SRAM_CELL
X_cell_55_22 WL55 BL[22] BLB[22] GND VDD SRAM_CELL
X_cell_55_23 WL55 BL[23] BLB[23] GND VDD SRAM_CELL
X_cell_55_24 WL55 BL[24] BLB[24] GND VDD SRAM_CELL
X_cell_55_25 WL55 BL[25] BLB[25] GND VDD SRAM_CELL
X_cell_55_26 WL55 BL[26] BLB[26] GND VDD SRAM_CELL
X_cell_55_27 WL55 BL[27] BLB[27] GND VDD SRAM_CELL
X_cell_55_28 WL55 BL[28] BLB[28] GND VDD SRAM_CELL
X_cell_55_29 WL55 BL[29] BLB[29] GND VDD SRAM_CELL
X_cell_55_30 WL55 BL[30] BLB[30] GND VDD SRAM_CELL
X_cell_55_31 WL55 BL[31] BLB[31] GND VDD SRAM_CELL
* Row 56
X_cell_56_0 WL56 BL[0] BLB[0] GND VDD SRAM_CELL
X_cell_56_1 WL56 BL[1] BLB[1] GND VDD SRAM_CELL
X_cell_56_2 WL56 BL[2] BLB[2] GND VDD SRAM_CELL
X_cell_56_3 WL56 BL[3] BLB[3] GND VDD SRAM_CELL
X_cell_56_4 WL56 BL[4] BLB[4] GND VDD SRAM_CELL
X_cell_56_5 WL56 BL[5] BLB[5] GND VDD SRAM_CELL
X_cell_56_6 WL56 BL[6] BLB[6] GND VDD SRAM_CELL
X_cell_56_7 WL56 BL[7] BLB[7] GND VDD SRAM_CELL
X_cell_56_8 WL56 BL[8] BLB[8] GND VDD SRAM_CELL
X_cell_56_9 WL56 BL[9] BLB[9] GND VDD SRAM_CELL
X_cell_56_10 WL56 BL[10] BLB[10] GND VDD SRAM_CELL
X_cell_56_11 WL56 BL[11] BLB[11] GND VDD SRAM_CELL
X_cell_56_12 WL56 BL[12] BLB[12] GND VDD SRAM_CELL
X_cell_56_13 WL56 BL[13] BLB[13] GND VDD SRAM_CELL
X_cell_56_14 WL56 BL[14] BLB[14] GND VDD SRAM_CELL
X_cell_56_15 WL56 BL[15] BLB[15] GND VDD SRAM_CELL
X_cell_56_16 WL56 BL[16] BLB[16] GND VDD SRAM_CELL
X_cell_56_17 WL56 BL[17] BLB[17] GND VDD SRAM_CELL
X_cell_56_18 WL56 BL[18] BLB[18] GND VDD SRAM_CELL
X_cell_56_19 WL56 BL[19] BLB[19] GND VDD SRAM_CELL
X_cell_56_20 WL56 BL[20] BLB[20] GND VDD SRAM_CELL
X_cell_56_21 WL56 BL[21] BLB[21] GND VDD SRAM_CELL
X_cell_56_22 WL56 BL[22] BLB[22] GND VDD SRAM_CELL
X_cell_56_23 WL56 BL[23] BLB[23] GND VDD SRAM_CELL
X_cell_56_24 WL56 BL[24] BLB[24] GND VDD SRAM_CELL
X_cell_56_25 WL56 BL[25] BLB[25] GND VDD SRAM_CELL
X_cell_56_26 WL56 BL[26] BLB[26] GND VDD SRAM_CELL
X_cell_56_27 WL56 BL[27] BLB[27] GND VDD SRAM_CELL
X_cell_56_28 WL56 BL[28] BLB[28] GND VDD SRAM_CELL
X_cell_56_29 WL56 BL[29] BLB[29] GND VDD SRAM_CELL
X_cell_56_30 WL56 BL[30] BLB[30] GND VDD SRAM_CELL
X_cell_56_31 WL56 BL[31] BLB[31] GND VDD SRAM_CELL
* Row 57
X_cell_57_0 WL57 BL[0] BLB[0] GND VDD SRAM_CELL
X_cell_57_1 WL57 BL[1] BLB[1] GND VDD SRAM_CELL
X_cell_57_2 WL57 BL[2] BLB[2] GND VDD SRAM_CELL
X_cell_57_3 WL57 BL[3] BLB[3] GND VDD SRAM_CELL
X_cell_57_4 WL57 BL[4] BLB[4] GND VDD SRAM_CELL
X_cell_57_5 WL57 BL[5] BLB[5] GND VDD SRAM_CELL
X_cell_57_6 WL57 BL[6] BLB[6] GND VDD SRAM_CELL
X_cell_57_7 WL57 BL[7] BLB[7] GND VDD SRAM_CELL
X_cell_57_8 WL57 BL[8] BLB[8] GND VDD SRAM_CELL
X_cell_57_9 WL57 BL[9] BLB[9] GND VDD SRAM_CELL
X_cell_57_10 WL57 BL[10] BLB[10] GND VDD SRAM_CELL
X_cell_57_11 WL57 BL[11] BLB[11] GND VDD SRAM_CELL
X_cell_57_12 WL57 BL[12] BLB[12] GND VDD SRAM_CELL
X_cell_57_13 WL57 BL[13] BLB[13] GND VDD SRAM_CELL
X_cell_57_14 WL57 BL[14] BLB[14] GND VDD SRAM_CELL
X_cell_57_15 WL57 BL[15] BLB[15] GND VDD SRAM_CELL
X_cell_57_16 WL57 BL[16] BLB[16] GND VDD SRAM_CELL
X_cell_57_17 WL57 BL[17] BLB[17] GND VDD SRAM_CELL
X_cell_57_18 WL57 BL[18] BLB[18] GND VDD SRAM_CELL
X_cell_57_19 WL57 BL[19] BLB[19] GND VDD SRAM_CELL
X_cell_57_20 WL57 BL[20] BLB[20] GND VDD SRAM_CELL
X_cell_57_21 WL57 BL[21] BLB[21] GND VDD SRAM_CELL
X_cell_57_22 WL57 BL[22] BLB[22] GND VDD SRAM_CELL
X_cell_57_23 WL57 BL[23] BLB[23] GND VDD SRAM_CELL
X_cell_57_24 WL57 BL[24] BLB[24] GND VDD SRAM_CELL
X_cell_57_25 WL57 BL[25] BLB[25] GND VDD SRAM_CELL
X_cell_57_26 WL57 BL[26] BLB[26] GND VDD SRAM_CELL
X_cell_57_27 WL57 BL[27] BLB[27] GND VDD SRAM_CELL
X_cell_57_28 WL57 BL[28] BLB[28] GND VDD SRAM_CELL
X_cell_57_29 WL57 BL[29] BLB[29] GND VDD SRAM_CELL
X_cell_57_30 WL57 BL[30] BLB[30] GND VDD SRAM_CELL
X_cell_57_31 WL57 BL[31] BLB[31] GND VDD SRAM_CELL
* Row 58
X_cell_58_0 WL58 BL[0] BLB[0] GND VDD SRAM_CELL
X_cell_58_1 WL58 BL[1] BLB[1] GND VDD SRAM_CELL
X_cell_58_2 WL58 BL[2] BLB[2] GND VDD SRAM_CELL
X_cell_58_3 WL58 BL[3] BLB[3] GND VDD SRAM_CELL
X_cell_58_4 WL58 BL[4] BLB[4] GND VDD SRAM_CELL
X_cell_58_5 WL58 BL[5] BLB[5] GND VDD SRAM_CELL
X_cell_58_6 WL58 BL[6] BLB[6] GND VDD SRAM_CELL
X_cell_58_7 WL58 BL[7] BLB[7] GND VDD SRAM_CELL
X_cell_58_8 WL58 BL[8] BLB[8] GND VDD SRAM_CELL
X_cell_58_9 WL58 BL[9] BLB[9] GND VDD SRAM_CELL
X_cell_58_10 WL58 BL[10] BLB[10] GND VDD SRAM_CELL
X_cell_58_11 WL58 BL[11] BLB[11] GND VDD SRAM_CELL
X_cell_58_12 WL58 BL[12] BLB[12] GND VDD SRAM_CELL
X_cell_58_13 WL58 BL[13] BLB[13] GND VDD SRAM_CELL
X_cell_58_14 WL58 BL[14] BLB[14] GND VDD SRAM_CELL
X_cell_58_15 WL58 BL[15] BLB[15] GND VDD SRAM_CELL
X_cell_58_16 WL58 BL[16] BLB[16] GND VDD SRAM_CELL
X_cell_58_17 WL58 BL[17] BLB[17] GND VDD SRAM_CELL
X_cell_58_18 WL58 BL[18] BLB[18] GND VDD SRAM_CELL
X_cell_58_19 WL58 BL[19] BLB[19] GND VDD SRAM_CELL
X_cell_58_20 WL58 BL[20] BLB[20] GND VDD SRAM_CELL
X_cell_58_21 WL58 BL[21] BLB[21] GND VDD SRAM_CELL
X_cell_58_22 WL58 BL[22] BLB[22] GND VDD SRAM_CELL
X_cell_58_23 WL58 BL[23] BLB[23] GND VDD SRAM_CELL
X_cell_58_24 WL58 BL[24] BLB[24] GND VDD SRAM_CELL
X_cell_58_25 WL58 BL[25] BLB[25] GND VDD SRAM_CELL
X_cell_58_26 WL58 BL[26] BLB[26] GND VDD SRAM_CELL
X_cell_58_27 WL58 BL[27] BLB[27] GND VDD SRAM_CELL
X_cell_58_28 WL58 BL[28] BLB[28] GND VDD SRAM_CELL
X_cell_58_29 WL58 BL[29] BLB[29] GND VDD SRAM_CELL
X_cell_58_30 WL58 BL[30] BLB[30] GND VDD SRAM_CELL
X_cell_58_31 WL58 BL[31] BLB[31] GND VDD SRAM_CELL
* Row 59
X_cell_59_0 WL59 BL[0] BLB[0] GND VDD SRAM_CELL
X_cell_59_1 WL59 BL[1] BLB[1] GND VDD SRAM_CELL
X_cell_59_2 WL59 BL[2] BLB[2] GND VDD SRAM_CELL
X_cell_59_3 WL59 BL[3] BLB[3] GND VDD SRAM_CELL
X_cell_59_4 WL59 BL[4] BLB[4] GND VDD SRAM_CELL
X_cell_59_5 WL59 BL[5] BLB[5] GND VDD SRAM_CELL
X_cell_59_6 WL59 BL[6] BLB[6] GND VDD SRAM_CELL
X_cell_59_7 WL59 BL[7] BLB[7] GND VDD SRAM_CELL
X_cell_59_8 WL59 BL[8] BLB[8] GND VDD SRAM_CELL
X_cell_59_9 WL59 BL[9] BLB[9] GND VDD SRAM_CELL
X_cell_59_10 WL59 BL[10] BLB[10] GND VDD SRAM_CELL
X_cell_59_11 WL59 BL[11] BLB[11] GND VDD SRAM_CELL
X_cell_59_12 WL59 BL[12] BLB[12] GND VDD SRAM_CELL
X_cell_59_13 WL59 BL[13] BLB[13] GND VDD SRAM_CELL
X_cell_59_14 WL59 BL[14] BLB[14] GND VDD SRAM_CELL
X_cell_59_15 WL59 BL[15] BLB[15] GND VDD SRAM_CELL
X_cell_59_16 WL59 BL[16] BLB[16] GND VDD SRAM_CELL
X_cell_59_17 WL59 BL[17] BLB[17] GND VDD SRAM_CELL
X_cell_59_18 WL59 BL[18] BLB[18] GND VDD SRAM_CELL
X_cell_59_19 WL59 BL[19] BLB[19] GND VDD SRAM_CELL
X_cell_59_20 WL59 BL[20] BLB[20] GND VDD SRAM_CELL
X_cell_59_21 WL59 BL[21] BLB[21] GND VDD SRAM_CELL
X_cell_59_22 WL59 BL[22] BLB[22] GND VDD SRAM_CELL
X_cell_59_23 WL59 BL[23] BLB[23] GND VDD SRAM_CELL
X_cell_59_24 WL59 BL[24] BLB[24] GND VDD SRAM_CELL
X_cell_59_25 WL59 BL[25] BLB[25] GND VDD SRAM_CELL
X_cell_59_26 WL59 BL[26] BLB[26] GND VDD SRAM_CELL
X_cell_59_27 WL59 BL[27] BLB[27] GND VDD SRAM_CELL
X_cell_59_28 WL59 BL[28] BLB[28] GND VDD SRAM_CELL
X_cell_59_29 WL59 BL[29] BLB[29] GND VDD SRAM_CELL
X_cell_59_30 WL59 BL[30] BLB[30] GND VDD SRAM_CELL
X_cell_59_31 WL59 BL[31] BLB[31] GND VDD SRAM_CELL
* Row 60
X_cell_60_0 WL60 BL[0] BLB[0] GND VDD SRAM_CELL
X_cell_60_1 WL60 BL[1] BLB[1] GND VDD SRAM_CELL
X_cell_60_2 WL60 BL[2] BLB[2] GND VDD SRAM_CELL
X_cell_60_3 WL60 BL[3] BLB[3] GND VDD SRAM_CELL
X_cell_60_4 WL60 BL[4] BLB[4] GND VDD SRAM_CELL
X_cell_60_5 WL60 BL[5] BLB[5] GND VDD SRAM_CELL
X_cell_60_6 WL60 BL[6] BLB[6] GND VDD SRAM_CELL
X_cell_60_7 WL60 BL[7] BLB[7] GND VDD SRAM_CELL
X_cell_60_8 WL60 BL[8] BLB[8] GND VDD SRAM_CELL
X_cell_60_9 WL60 BL[9] BLB[9] GND VDD SRAM_CELL
X_cell_60_10 WL60 BL[10] BLB[10] GND VDD SRAM_CELL
X_cell_60_11 WL60 BL[11] BLB[11] GND VDD SRAM_CELL
X_cell_60_12 WL60 BL[12] BLB[12] GND VDD SRAM_CELL
X_cell_60_13 WL60 BL[13] BLB[13] GND VDD SRAM_CELL
X_cell_60_14 WL60 BL[14] BLB[14] GND VDD SRAM_CELL
X_cell_60_15 WL60 BL[15] BLB[15] GND VDD SRAM_CELL
X_cell_60_16 WL60 BL[16] BLB[16] GND VDD SRAM_CELL
X_cell_60_17 WL60 BL[17] BLB[17] GND VDD SRAM_CELL
X_cell_60_18 WL60 BL[18] BLB[18] GND VDD SRAM_CELL
X_cell_60_19 WL60 BL[19] BLB[19] GND VDD SRAM_CELL
X_cell_60_20 WL60 BL[20] BLB[20] GND VDD SRAM_CELL
X_cell_60_21 WL60 BL[21] BLB[21] GND VDD SRAM_CELL
X_cell_60_22 WL60 BL[22] BLB[22] GND VDD SRAM_CELL
X_cell_60_23 WL60 BL[23] BLB[23] GND VDD SRAM_CELL
X_cell_60_24 WL60 BL[24] BLB[24] GND VDD SRAM_CELL
X_cell_60_25 WL60 BL[25] BLB[25] GND VDD SRAM_CELL
X_cell_60_26 WL60 BL[26] BLB[26] GND VDD SRAM_CELL
X_cell_60_27 WL60 BL[27] BLB[27] GND VDD SRAM_CELL
X_cell_60_28 WL60 BL[28] BLB[28] GND VDD SRAM_CELL
X_cell_60_29 WL60 BL[29] BLB[29] GND VDD SRAM_CELL
X_cell_60_30 WL60 BL[30] BLB[30] GND VDD SRAM_CELL
X_cell_60_31 WL60 BL[31] BLB[31] GND VDD SRAM_CELL
* Row 61
X_cell_61_0 WL61 BL[0] BLB[0] GND VDD SRAM_CELL
X_cell_61_1 WL61 BL[1] BLB[1] GND VDD SRAM_CELL
X_cell_61_2 WL61 BL[2] BLB[2] GND VDD SRAM_CELL
X_cell_61_3 WL61 BL[3] BLB[3] GND VDD SRAM_CELL
X_cell_61_4 WL61 BL[4] BLB[4] GND VDD SRAM_CELL
X_cell_61_5 WL61 BL[5] BLB[5] GND VDD SRAM_CELL
X_cell_61_6 WL61 BL[6] BLB[6] GND VDD SRAM_CELL
X_cell_61_7 WL61 BL[7] BLB[7] GND VDD SRAM_CELL
X_cell_61_8 WL61 BL[8] BLB[8] GND VDD SRAM_CELL
X_cell_61_9 WL61 BL[9] BLB[9] GND VDD SRAM_CELL
X_cell_61_10 WL61 BL[10] BLB[10] GND VDD SRAM_CELL
X_cell_61_11 WL61 BL[11] BLB[11] GND VDD SRAM_CELL
X_cell_61_12 WL61 BL[12] BLB[12] GND VDD SRAM_CELL
X_cell_61_13 WL61 BL[13] BLB[13] GND VDD SRAM_CELL
X_cell_61_14 WL61 BL[14] BLB[14] GND VDD SRAM_CELL
X_cell_61_15 WL61 BL[15] BLB[15] GND VDD SRAM_CELL
X_cell_61_16 WL61 BL[16] BLB[16] GND VDD SRAM_CELL
X_cell_61_17 WL61 BL[17] BLB[17] GND VDD SRAM_CELL
X_cell_61_18 WL61 BL[18] BLB[18] GND VDD SRAM_CELL
X_cell_61_19 WL61 BL[19] BLB[19] GND VDD SRAM_CELL
X_cell_61_20 WL61 BL[20] BLB[20] GND VDD SRAM_CELL
X_cell_61_21 WL61 BL[21] BLB[21] GND VDD SRAM_CELL
X_cell_61_22 WL61 BL[22] BLB[22] GND VDD SRAM_CELL
X_cell_61_23 WL61 BL[23] BLB[23] GND VDD SRAM_CELL
X_cell_61_24 WL61 BL[24] BLB[24] GND VDD SRAM_CELL
X_cell_61_25 WL61 BL[25] BLB[25] GND VDD SRAM_CELL
X_cell_61_26 WL61 BL[26] BLB[26] GND VDD SRAM_CELL
X_cell_61_27 WL61 BL[27] BLB[27] GND VDD SRAM_CELL
X_cell_61_28 WL61 BL[28] BLB[28] GND VDD SRAM_CELL
X_cell_61_29 WL61 BL[29] BLB[29] GND VDD SRAM_CELL
X_cell_61_30 WL61 BL[30] BLB[30] GND VDD SRAM_CELL
X_cell_61_31 WL61 BL[31] BLB[31] GND VDD SRAM_CELL
* Row 62
X_cell_62_0 WL62 BL[0] BLB[0] GND VDD SRAM_CELL
X_cell_62_1 WL62 BL[1] BLB[1] GND VDD SRAM_CELL
X_cell_62_2 WL62 BL[2] BLB[2] GND VDD SRAM_CELL
X_cell_62_3 WL62 BL[3] BLB[3] GND VDD SRAM_CELL
X_cell_62_4 WL62 BL[4] BLB[4] GND VDD SRAM_CELL
X_cell_62_5 WL62 BL[5] BLB[5] GND VDD SRAM_CELL
X_cell_62_6 WL62 BL[6] BLB[6] GND VDD SRAM_CELL
X_cell_62_7 WL62 BL[7] BLB[7] GND VDD SRAM_CELL
X_cell_62_8 WL62 BL[8] BLB[8] GND VDD SRAM_CELL
X_cell_62_9 WL62 BL[9] BLB[9] GND VDD SRAM_CELL
X_cell_62_10 WL62 BL[10] BLB[10] GND VDD SRAM_CELL
X_cell_62_11 WL62 BL[11] BLB[11] GND VDD SRAM_CELL
X_cell_62_12 WL62 BL[12] BLB[12] GND VDD SRAM_CELL
X_cell_62_13 WL62 BL[13] BLB[13] GND VDD SRAM_CELL
X_cell_62_14 WL62 BL[14] BLB[14] GND VDD SRAM_CELL
X_cell_62_15 WL62 BL[15] BLB[15] GND VDD SRAM_CELL
X_cell_62_16 WL62 BL[16] BLB[16] GND VDD SRAM_CELL
X_cell_62_17 WL62 BL[17] BLB[17] GND VDD SRAM_CELL
X_cell_62_18 WL62 BL[18] BLB[18] GND VDD SRAM_CELL
X_cell_62_19 WL62 BL[19] BLB[19] GND VDD SRAM_CELL
X_cell_62_20 WL62 BL[20] BLB[20] GND VDD SRAM_CELL
X_cell_62_21 WL62 BL[21] BLB[21] GND VDD SRAM_CELL
X_cell_62_22 WL62 BL[22] BLB[22] GND VDD SRAM_CELL
X_cell_62_23 WL62 BL[23] BLB[23] GND VDD SRAM_CELL
X_cell_62_24 WL62 BL[24] BLB[24] GND VDD SRAM_CELL
X_cell_62_25 WL62 BL[25] BLB[25] GND VDD SRAM_CELL
X_cell_62_26 WL62 BL[26] BLB[26] GND VDD SRAM_CELL
X_cell_62_27 WL62 BL[27] BLB[27] GND VDD SRAM_CELL
X_cell_62_28 WL62 BL[28] BLB[28] GND VDD SRAM_CELL
X_cell_62_29 WL62 BL[29] BLB[29] GND VDD SRAM_CELL
X_cell_62_30 WL62 BL[30] BLB[30] GND VDD SRAM_CELL
X_cell_62_31 WL62 BL[31] BLB[31] GND VDD SRAM_CELL
* Row 63
X_cell_63_0 WL63 BL[0] BLB[0] GND VDD SRAM_CELL
X_cell_63_1 WL63 BL[1] BLB[1] GND VDD SRAM_CELL
X_cell_63_2 WL63 BL[2] BLB[2] GND VDD SRAM_CELL
X_cell_63_3 WL63 BL[3] BLB[3] GND VDD SRAM_CELL
X_cell_63_4 WL63 BL[4] BLB[4] GND VDD SRAM_CELL
X_cell_63_5 WL63 BL[5] BLB[5] GND VDD SRAM_CELL
X_cell_63_6 WL63 BL[6] BLB[6] GND VDD SRAM_CELL
X_cell_63_7 WL63 BL[7] BLB[7] GND VDD SRAM_CELL
X_cell_63_8 WL63 BL[8] BLB[8] GND VDD SRAM_CELL
X_cell_63_9 WL63 BL[9] BLB[9] GND VDD SRAM_CELL
X_cell_63_10 WL63 BL[10] BLB[10] GND VDD SRAM_CELL
X_cell_63_11 WL63 BL[11] BLB[11] GND VDD SRAM_CELL
X_cell_63_12 WL63 BL[12] BLB[12] GND VDD SRAM_CELL
X_cell_63_13 WL63 BL[13] BLB[13] GND VDD SRAM_CELL
X_cell_63_14 WL63 BL[14] BLB[14] GND VDD SRAM_CELL
X_cell_63_15 WL63 BL[15] BLB[15] GND VDD SRAM_CELL
X_cell_63_16 WL63 BL[16] BLB[16] GND VDD SRAM_CELL
X_cell_63_17 WL63 BL[17] BLB[17] GND VDD SRAM_CELL
X_cell_63_18 WL63 BL[18] BLB[18] GND VDD SRAM_CELL
X_cell_63_19 WL63 BL[19] BLB[19] GND VDD SRAM_CELL
X_cell_63_20 WL63 BL[20] BLB[20] GND VDD SRAM_CELL
X_cell_63_21 WL63 BL[21] BLB[21] GND VDD SRAM_CELL
X_cell_63_22 WL63 BL[22] BLB[22] GND VDD SRAM_CELL
X_cell_63_23 WL63 BL[23] BLB[23] GND VDD SRAM_CELL
X_cell_63_24 WL63 BL[24] BLB[24] GND VDD SRAM_CELL
X_cell_63_25 WL63 BL[25] BLB[25] GND VDD SRAM_CELL
X_cell_63_26 WL63 BL[26] BLB[26] GND VDD SRAM_CELL
X_cell_63_27 WL63 BL[27] BLB[27] GND VDD SRAM_CELL
X_cell_63_28 WL63 BL[28] BLB[28] GND VDD SRAM_CELL
X_cell_63_29 WL63 BL[29] BLB[29] GND VDD SRAM_CELL
X_cell_63_30 WL63 BL[30] BLB[30] GND VDD SRAM_CELL
X_cell_63_31 WL63 BL[31] BLB[31] GND VDD SRAM_CELL

X_COL0  A0_sel0 A0_sel1 D0  WR_EN CLK SAEN PRE BL[0]  BLB[0]  BL[1]  BLB[1]  Q0  COL_PERIPHERAL
X_COL1  A0_sel0 A0_sel1 D1  WR_EN CLK SAEN PRE BL[2]  BLB[2]  BL[3]  BLB[3]  Q1  COL_PERIPHERAL
X_COL2  A0_sel0 A0_sel1 D2  WR_EN CLK SAEN PRE BL[4]  BLB[4]  BL[5]  BLB[5]  Q2  COL_PERIPHERAL
X_COL3  A0_sel0 A0_sel1 D3  WR_EN CLK SAEN PRE BL[6]  BLB[6]  BL[7]  BLB[7]  Q3  COL_PERIPHERAL
X_COL4  A0_sel0 A0_sel1 D4  WR_EN CLK SAEN PRE BL[8]  BLB[8]  BL[9]  BLB[9]  Q4  COL_PERIPHERAL
X_COL5  A0_sel0 A0_sel1 D5  WR_EN CLK SAEN PRE BL[10] BLB[10] BL[11] BLB[11] Q5  COL_PERIPHERAL
X_COL6  A0_sel0 A0_sel1 D6  WR_EN CLK SAEN PRE BL[12] BLB[12] BL[13] BLB[13] Q6  COL_PERIPHERAL
X_COL7  A0_sel0 A0_sel1 D7  WR_EN CLK SAEN PRE BL[14] BLB[14] BL[15] BLB[15] Q7  COL_PERIPHERAL
X_COL8  A0_sel0 A0_sel1 D8  WR_EN CLK SAEN PRE BL[16] BLB[16] BL[17] BLB[17] Q8  COL_PERIPHERAL
X_COL9  A0_sel0 A0_sel1 D9  WR_EN CLK SAEN PRE BL[18] BLB[18] BL[19] BLB[19] Q9  COL_PERIPHERAL
X_COL10 A0_sel0 A0_sel1 D10 WR_EN CLK SAEN PRE BL[20] BLB[20] BL[21] BLB[21] Q10 COL_PERIPHERAL
X_COL11 A0_sel0 A0_sel1 D11 WR_EN CLK SAEN PRE BL[22] BLB[22] BL[23] BLB[23] Q11 COL_PERIPHERAL
X_COL12 A0_sel0 A0_sel1 D12 WR_EN CLK SAEN PRE BL[24] BLB[24] BL[25] BLB[25] Q12 COL_PERIPHERAL
X_COL13 A0_sel0 A0_sel1 D13 WR_EN CLK SAEN PRE BL[26] BLB[26] BL[27] BLB[27] Q13 COL_PERIPHERAL
X_COL14 A0_sel0 A0_sel1 D14 WR_EN CLK SAEN PRE BL[28] BLB[28] BL[29] BLB[29] Q14 COL_PERIPHERAL
X_COL15 A0_sel0 A0_sel1 D15 WR_EN CLK SAEN PRE BL[30] BLB[30] BL[31] BLB[31] Q15 COL_PERIPHERAL

* ======================================================================
* 5. 激發訊號
* ======================================================================
V_CLK_IN CLK_raw GND PULSE(0 'SUP' 0n 50p 50p 0.95n 2n)
V_WEN_IN WEN_raw GND PWL(0 0V  5.9n 0V  5.95n 'SUP'  12n 'SUP')
V_A0_IN A_raw0 GND PWL(0 0, 1.9n 0, 1.95n 'SUP', 3.9n 'SUP', 3.95n 0, 7.9n 0, 7.95n 'SUP', 9.9n 'SUP', 9.95n 0, 12n 0)
V_A1_IN A_raw1 GND PWL(0 0, 3.9n 0, 3.95n 'SUP', 5.9n 'SUP', 5.95n 0, 9.9n 0, 9.95n 'SUP', 12n 'SUP')

V_A2_IN A_raw2 GND 0V
V_A3_IN A_raw3 GND 0V
V_A4_IN A_raw4 GND 0V
V_A5_IN A_raw5 GND 0V
V_A6_IN A_raw6 GND 0V

V_D0  D_raw0  GND PWL(0 0, 3.9n 0, 3.95n 'SUP', 12n 'SUP')
V_D1  D_raw1  GND 0V
V_D2  D_raw2  GND PWL(0 'SUP', 1.9n 'SUP', 1.95n 0, 3.9n 0, 3.95n 'SUP', 12n 'SUP')
V_D3  D_raw3  GND PWL(0 0, 1.9n 0, 1.95n 'SUP', 12n 'SUP')
V_D4  D_raw4  GND PWL(0 'SUP', 3.9n 'SUP', 3.95n 0, 12n 0)
V_D5  D_raw5  GND PWL(0 'SUP', 3.9n 'SUP', 3.95n 0, 12n 0)
V_D6  D_raw6  GND PWL(0 0, 1.9n 0, 1.95n 'SUP', 12n 'SUP')
V_D7  D_raw7  GND PWL(0 0, 3.9n 0, 3.95n 'SUP', 12n 'SUP')
V_D8  D_raw8  GND PWL(0 0, 3.9n 0, 3.95n 'SUP', 12n 'SUP')
V_D9  D_raw9  GND 'SUP'
V_D10 D_raw10 GND PWL(0 0, 1.9n 0, 1.95n 'SUP', 3.9n 'SUP', 3.95n 0, 12n 0)
V_D11 D_raw11 GND PWL(0 0, 3.9n 0, 3.95n 'SUP', 12n 'SUP')
V_D12 D_raw12 GND PWL(0 'SUP', 3.9n 'SUP', 3.95n 0, 12n 0)
V_D13 D_raw13 GND PWL(0 0, 3.9n 0, 3.95n 'SUP', 12n 'SUP')
V_D14 D_raw14 GND PWL(0 0, 1.9n 0, 1.95n 'SUP', 3.9n 'SUP', 3.95n 0, 12n 0)
V_D15 D_raw15 GND PWL(0 0, 3.9n 0, 3.95n 'SUP', 12n 'SUP')

Xbuf_clk_m CLK_raw clk_m BUF_MIN
Xtree_clk  clk_m   CLK   BUF_X64
Xbuf_wen_m WEN_raw wen_m BUF_MIN
Xtree_wen  wen_m   WEN   BUF_X64
Xbuf_a0_m A_raw0 a0_m BUF_MIN
Xtree_a0  a0_m   A0   BUF_X64
Xbuf_a1_m A_raw1 a1_m BUF_MIN
Xtree_a1  a1_m   A1   BUF_X64
Xbuf_a2_m A_raw2 a2_m BUF_MIN
Xtree_a2  a2_m   A2   BUF_X16
Xbuf_a3_m A_raw3 a3_m BUF_MIN
Xtree_a3  a3_m   A3   BUF_X16
Xbuf_a4_m A_raw4 a4_m BUF_MIN
Xtree_a4  a4_m   A4   BUF_X16
Xbuf_a5_m A_raw5 a5_m BUF_MIN
Xtree_a5  a5_m   A5   BUF_X16
Xbuf_a6_m A_raw6 a6_m BUF_MIN
Xtree_a6  a6_m   A6   BUF_X16
Xbuf_d0_m  D_raw0  d0_m  BUF_MIN
Xtree_d0   d0_m    D0    BUF_X16
Xbuf_d1_m  D_raw1  d1_m  BUF_MIN
Xtree_d1   d1_m    D1    BUF_X16
Xbuf_d2_m  D_raw2  d2_m  BUF_MIN
Xtree_d2   d2_m    D2    BUF_X16
Xbuf_d3_m  D_raw3  d3_m  BUF_MIN
Xtree_d3   d3_m    D3    BUF_X16
Xbuf_d4_m  D_raw4  d4_m  BUF_MIN
Xtree_d4   d4_m    D4    BUF_X16
Xbuf_d5_m  D_raw5  d5_m  BUF_MIN
Xtree_d5   d5_m    D5    BUF_X16
Xbuf_d6_m  D_raw6  d6_m  BUF_MIN
Xtree_d6   d6_m    D6    BUF_X16
Xbuf_d7_m  D_raw7  d7_m  BUF_MIN
Xtree_d7   d7_m    D7    BUF_X16
Xbuf_d8_m  D_raw8  d8_m  BUF_MIN
Xtree_d8   d8_m    D8    BUF_X16
Xbuf_d9_m  D_raw9  d9_m  BUF_MIN
Xtree_d9   d9_m    D9    BUF_X16
Xbuf_d10_m D_raw10 d10_m BUF_MIN
Xtree_d10  d10_m   D10   BUF_X16
Xbuf_d11_m D_raw11 d11_m BUF_MIN
Xtree_d11  d11_m   D11   BUF_X16
Xbuf_d12_m D_raw12 d12_m BUF_MIN
Xtree_d12  d12_m   D12   BUF_X16
Xbuf_d13_m D_raw13 d13_m BUF_MIN
Xtree_d13  d13_m   D13   BUF_X16
Xbuf_d14_m D_raw14 d14_m BUF_MIN
Xtree_d14  d14_m   D14   BUF_X16
Xbuf_d15_m D_raw15 d15_m BUF_MIN
Xtree_d15  d15_m   D15   BUF_X16

* 6. 模擬設定
.TRAN 10p 13ns
.END
