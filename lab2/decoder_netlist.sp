* 6-to-64 Row Decoder Netlist Generated by Python

.SUBCKT INV IN OUT VDD VSS
Mp1 OUT IN VDD VDD pmos_rvt NFIN=4 L=21n
Mn1 OUT IN VSS VSS nmos_rvt NFIN=2 L=21n
.ENDS INV

.SUBCKT NAND2 A B OUT VDD VSS
Mp1 OUT A VDD VDD pmos_rvt NFIN=4 L=21n
Mp2 OUT B VDD VDD pmos_rvt NFIN=4 L=21n
Mn1 OUT A net1 VSS nmos_rvt NFIN=4 L=21n
Mn2 net1 B VSS VSS nmos_rvt NFIN=4 L=21n
.ENDS NAND2

.SUBCKT NAND3 A B C OUT VDD VSS
Mp1 OUT A VDD VDD pmos_rvt NFIN=6 L=21n
Mp2 OUT B VDD VDD pmos_rvt NFIN=6 L=21n
Mp3 OUT C VDD VDD pmos_rvt NFIN=6 L=21n
Mn1 OUT A n1 VSS nmos_rvt NFIN=6 L=21n
Mn2 n1 B n2 VSS nmos_rvt NFIN=6 L=21n
Mn3 n2 C VSS VSS nmos_rvt NFIN=6 L=21n
.ENDS NAND3

.SUBCKT INV_DRV IN OUT VDD VSS
Mp1 OUT IN VDD VDD pmos_rvt NFIN=16 L=21n
Mn1 OUT IN VSS VSS nmos_rvt NFIN=8 L=21n
.ENDS INV_DRV

.SUBCKT ROW_DECODER A5 A4 A3 A2 A1 A0 WL0 WL1 WL2 WL3 WL4 WL5 WL6 WL7 WL8 WL9 WL10 WL11 WL12 WL13 WL14 WL15 WL16 WL17 WL18 WL19 WL20 WL21 WL22 WL23 WL24 WL25 WL26 WL27 WL28 WL29 WL30 WL31 WL32 WL33 WL34 WL35 WL36 WL37 WL38 WL39 WL40 WL41 WL42 WL43 WL44 WL45 WL46 WL47 WL48 WL49 WL50 WL51 WL52 WL53 WL54 WL55 WL56 WL57 WL58 WL59 WL60 WL61 WL62 WL63 VDD VSS

* Input Buffers & Inversions
Xbuf1_0 A0 A_buf_tmp0 VDD VSS INV
Xbuf2_0 A_buf_tmp0 A_T0 VDD VSS INV
Xinv_0 A_T0 A_F0 VDD VSS INV
Xbuf1_1 A1 A_buf_tmp1 VDD VSS INV
Xbuf2_1 A_buf_tmp1 A_T1 VDD VSS INV
Xinv_1 A_T1 A_F1 VDD VSS INV
Xbuf1_2 A2 A_buf_tmp2 VDD VSS INV
Xbuf2_2 A_buf_tmp2 A_T2 VDD VSS INV
Xinv_2 A_T2 A_F2 VDD VSS INV
Xbuf1_3 A3 A_buf_tmp3 VDD VSS INV
Xbuf2_3 A_buf_tmp3 A_T3 VDD VSS INV
Xinv_3 A_T3 A_F3 VDD VSS INV
Xbuf1_4 A4 A_buf_tmp4 VDD VSS INV
Xbuf2_4 A_buf_tmp4 A_T4 VDD VSS INV
Xinv_4 A_T4 A_F4 VDD VSS INV
Xbuf1_5 A5 A_buf_tmp5 VDD VSS INV
Xbuf2_5 A_buf_tmp5 A_T5 VDD VSS INV
Xinv_5 A_T5 A_F5 VDD VSS INV

* Pre-decoder 1 (A[2:0] -> X[7:0])
X_nand_x0 A_F2 A_F1 A_F0 X_bar_0 VDD VSS NAND3
X_inv_x0 X_bar_0 X_0 VDD VSS INV
X_nand_x1 A_F2 A_F1 A_T0 X_bar_1 VDD VSS NAND3
X_inv_x1 X_bar_1 X_1 VDD VSS INV
X_nand_x2 A_F2 A_T1 A_F0 X_bar_2 VDD VSS NAND3
X_inv_x2 X_bar_2 X_2 VDD VSS INV
X_nand_x3 A_F2 A_T1 A_T0 X_bar_3 VDD VSS NAND3
X_inv_x3 X_bar_3 X_3 VDD VSS INV
X_nand_x4 A_T2 A_F1 A_F0 X_bar_4 VDD VSS NAND3
X_inv_x4 X_bar_4 X_4 VDD VSS INV
X_nand_x5 A_T2 A_F1 A_T0 X_bar_5 VDD VSS NAND3
X_inv_x5 X_bar_5 X_5 VDD VSS INV
X_nand_x6 A_T2 A_T1 A_F0 X_bar_6 VDD VSS NAND3
X_inv_x6 X_bar_6 X_6 VDD VSS INV
X_nand_x7 A_T2 A_T1 A_T0 X_bar_7 VDD VSS NAND3
X_inv_x7 X_bar_7 X_7 VDD VSS INV
* Pre-decoder 2 (A[5:3] -> Y[7:0])
X_nand_y0 A_F5 A_F4 A_F3 Y_bar_0 VDD VSS NAND3
X_inv_y0 Y_bar_0 Y_0 VDD VSS INV
X_nand_y1 A_F5 A_F4 A_T3 Y_bar_1 VDD VSS NAND3
X_inv_y1 Y_bar_1 Y_1 VDD VSS INV
X_nand_y2 A_F5 A_T4 A_F3 Y_bar_2 VDD VSS NAND3
X_inv_y2 Y_bar_2 Y_2 VDD VSS INV
X_nand_y3 A_F5 A_T4 A_T3 Y_bar_3 VDD VSS NAND3
X_inv_y3 Y_bar_3 Y_3 VDD VSS INV
X_nand_y4 A_T5 A_F4 A_F3 Y_bar_4 VDD VSS NAND3
X_inv_y4 Y_bar_4 Y_4 VDD VSS INV
X_nand_y5 A_T5 A_F4 A_T3 Y_bar_5 VDD VSS NAND3
X_inv_y5 Y_bar_5 Y_5 VDD VSS INV
X_nand_y6 A_T5 A_T4 A_F3 Y_bar_6 VDD VSS NAND3
X_inv_y6 Y_bar_6 Y_6 VDD VSS INV
X_nand_y7 A_T5 A_T4 A_T3 Y_bar_7 VDD VSS NAND3
X_inv_y7 Y_bar_7 Y_7 VDD VSS INV

* Final Stage (X[i] + Y[j] -> WL[k])
X_final_nand_0 X_0 Y_0 WL_bar_0 VDD VSS NAND2
X_final_inv_0 WL_bar_0 WL0 VDD VSS INV_DRV
X_final_nand_1 X_1 Y_0 WL_bar_1 VDD VSS NAND2
X_final_inv_1 WL_bar_1 WL1 VDD VSS INV_DRV
X_final_nand_2 X_2 Y_0 WL_bar_2 VDD VSS NAND2
X_final_inv_2 WL_bar_2 WL2 VDD VSS INV_DRV
X_final_nand_3 X_3 Y_0 WL_bar_3 VDD VSS NAND2
X_final_inv_3 WL_bar_3 WL3 VDD VSS INV_DRV
X_final_nand_4 X_4 Y_0 WL_bar_4 VDD VSS NAND2
X_final_inv_4 WL_bar_4 WL4 VDD VSS INV_DRV
X_final_nand_5 X_5 Y_0 WL_bar_5 VDD VSS NAND2
X_final_inv_5 WL_bar_5 WL5 VDD VSS INV_DRV
X_final_nand_6 X_6 Y_0 WL_bar_6 VDD VSS NAND2
X_final_inv_6 WL_bar_6 WL6 VDD VSS INV_DRV
X_final_nand_7 X_7 Y_0 WL_bar_7 VDD VSS NAND2
X_final_inv_7 WL_bar_7 WL7 VDD VSS INV_DRV
X_final_nand_8 X_0 Y_1 WL_bar_8 VDD VSS NAND2
X_final_inv_8 WL_bar_8 WL8 VDD VSS INV_DRV
X_final_nand_9 X_1 Y_1 WL_bar_9 VDD VSS NAND2
X_final_inv_9 WL_bar_9 WL9 VDD VSS INV_DRV
X_final_nand_10 X_2 Y_1 WL_bar_10 VDD VSS NAND2
X_final_inv_10 WL_bar_10 WL10 VDD VSS INV_DRV
X_final_nand_11 X_3 Y_1 WL_bar_11 VDD VSS NAND2
X_final_inv_11 WL_bar_11 WL11 VDD VSS INV_DRV
X_final_nand_12 X_4 Y_1 WL_bar_12 VDD VSS NAND2
X_final_inv_12 WL_bar_12 WL12 VDD VSS INV_DRV
X_final_nand_13 X_5 Y_1 WL_bar_13 VDD VSS NAND2
X_final_inv_13 WL_bar_13 WL13 VDD VSS INV_DRV
X_final_nand_14 X_6 Y_1 WL_bar_14 VDD VSS NAND2
X_final_inv_14 WL_bar_14 WL14 VDD VSS INV_DRV
X_final_nand_15 X_7 Y_1 WL_bar_15 VDD VSS NAND2
X_final_inv_15 WL_bar_15 WL15 VDD VSS INV_DRV
X_final_nand_16 X_0 Y_2 WL_bar_16 VDD VSS NAND2
X_final_inv_16 WL_bar_16 WL16 VDD VSS INV_DRV
X_final_nand_17 X_1 Y_2 WL_bar_17 VDD VSS NAND2
X_final_inv_17 WL_bar_17 WL17 VDD VSS INV_DRV
X_final_nand_18 X_2 Y_2 WL_bar_18 VDD VSS NAND2
X_final_inv_18 WL_bar_18 WL18 VDD VSS INV_DRV
X_final_nand_19 X_3 Y_2 WL_bar_19 VDD VSS NAND2
X_final_inv_19 WL_bar_19 WL19 VDD VSS INV_DRV
X_final_nand_20 X_4 Y_2 WL_bar_20 VDD VSS NAND2
X_final_inv_20 WL_bar_20 WL20 VDD VSS INV_DRV
X_final_nand_21 X_5 Y_2 WL_bar_21 VDD VSS NAND2
X_final_inv_21 WL_bar_21 WL21 VDD VSS INV_DRV
X_final_nand_22 X_6 Y_2 WL_bar_22 VDD VSS NAND2
X_final_inv_22 WL_bar_22 WL22 VDD VSS INV_DRV
X_final_nand_23 X_7 Y_2 WL_bar_23 VDD VSS NAND2
X_final_inv_23 WL_bar_23 WL23 VDD VSS INV_DRV
X_final_nand_24 X_0 Y_3 WL_bar_24 VDD VSS NAND2
X_final_inv_24 WL_bar_24 WL24 VDD VSS INV_DRV
X_final_nand_25 X_1 Y_3 WL_bar_25 VDD VSS NAND2
X_final_inv_25 WL_bar_25 WL25 VDD VSS INV_DRV
X_final_nand_26 X_2 Y_3 WL_bar_26 VDD VSS NAND2
X_final_inv_26 WL_bar_26 WL26 VDD VSS INV_DRV
X_final_nand_27 X_3 Y_3 WL_bar_27 VDD VSS NAND2
X_final_inv_27 WL_bar_27 WL27 VDD VSS INV_DRV
X_final_nand_28 X_4 Y_3 WL_bar_28 VDD VSS NAND2
X_final_inv_28 WL_bar_28 WL28 VDD VSS INV_DRV
X_final_nand_29 X_5 Y_3 WL_bar_29 VDD VSS NAND2
X_final_inv_29 WL_bar_29 WL29 VDD VSS INV_DRV
X_final_nand_30 X_6 Y_3 WL_bar_30 VDD VSS NAND2
X_final_inv_30 WL_bar_30 WL30 VDD VSS INV_DRV
X_final_nand_31 X_7 Y_3 WL_bar_31 VDD VSS NAND2
X_final_inv_31 WL_bar_31 WL31 VDD VSS INV_DRV
X_final_nand_32 X_0 Y_4 WL_bar_32 VDD VSS NAND2
X_final_inv_32 WL_bar_32 WL32 VDD VSS INV_DRV
X_final_nand_33 X_1 Y_4 WL_bar_33 VDD VSS NAND2
X_final_inv_33 WL_bar_33 WL33 VDD VSS INV_DRV
X_final_nand_34 X_2 Y_4 WL_bar_34 VDD VSS NAND2
X_final_inv_34 WL_bar_34 WL34 VDD VSS INV_DRV
X_final_nand_35 X_3 Y_4 WL_bar_35 VDD VSS NAND2
X_final_inv_35 WL_bar_35 WL35 VDD VSS INV_DRV
X_final_nand_36 X_4 Y_4 WL_bar_36 VDD VSS NAND2
X_final_inv_36 WL_bar_36 WL36 VDD VSS INV_DRV
X_final_nand_37 X_5 Y_4 WL_bar_37 VDD VSS NAND2
X_final_inv_37 WL_bar_37 WL37 VDD VSS INV_DRV
X_final_nand_38 X_6 Y_4 WL_bar_38 VDD VSS NAND2
X_final_inv_38 WL_bar_38 WL38 VDD VSS INV_DRV
X_final_nand_39 X_7 Y_4 WL_bar_39 VDD VSS NAND2
X_final_inv_39 WL_bar_39 WL39 VDD VSS INV_DRV
X_final_nand_40 X_0 Y_5 WL_bar_40 VDD VSS NAND2
X_final_inv_40 WL_bar_40 WL40 VDD VSS INV_DRV
X_final_nand_41 X_1 Y_5 WL_bar_41 VDD VSS NAND2
X_final_inv_41 WL_bar_41 WL41 VDD VSS INV_DRV
X_final_nand_42 X_2 Y_5 WL_bar_42 VDD VSS NAND2
X_final_inv_42 WL_bar_42 WL42 VDD VSS INV_DRV
X_final_nand_43 X_3 Y_5 WL_bar_43 VDD VSS NAND2
X_final_inv_43 WL_bar_43 WL43 VDD VSS INV_DRV
X_final_nand_44 X_4 Y_5 WL_bar_44 VDD VSS NAND2
X_final_inv_44 WL_bar_44 WL44 VDD VSS INV_DRV
X_final_nand_45 X_5 Y_5 WL_bar_45 VDD VSS NAND2
X_final_inv_45 WL_bar_45 WL45 VDD VSS INV_DRV
X_final_nand_46 X_6 Y_5 WL_bar_46 VDD VSS NAND2
X_final_inv_46 WL_bar_46 WL46 VDD VSS INV_DRV
X_final_nand_47 X_7 Y_5 WL_bar_47 VDD VSS NAND2
X_final_inv_47 WL_bar_47 WL47 VDD VSS INV_DRV
X_final_nand_48 X_0 Y_6 WL_bar_48 VDD VSS NAND2
X_final_inv_48 WL_bar_48 WL48 VDD VSS INV_DRV
X_final_nand_49 X_1 Y_6 WL_bar_49 VDD VSS NAND2
X_final_inv_49 WL_bar_49 WL49 VDD VSS INV_DRV
X_final_nand_50 X_2 Y_6 WL_bar_50 VDD VSS NAND2
X_final_inv_50 WL_bar_50 WL50 VDD VSS INV_DRV
X_final_nand_51 X_3 Y_6 WL_bar_51 VDD VSS NAND2
X_final_inv_51 WL_bar_51 WL51 VDD VSS INV_DRV
X_final_nand_52 X_4 Y_6 WL_bar_52 VDD VSS NAND2
X_final_inv_52 WL_bar_52 WL52 VDD VSS INV_DRV
X_final_nand_53 X_5 Y_6 WL_bar_53 VDD VSS NAND2
X_final_inv_53 WL_bar_53 WL53 VDD VSS INV_DRV
X_final_nand_54 X_6 Y_6 WL_bar_54 VDD VSS NAND2
X_final_inv_54 WL_bar_54 WL54 VDD VSS INV_DRV
X_final_nand_55 X_7 Y_6 WL_bar_55 VDD VSS NAND2
X_final_inv_55 WL_bar_55 WL55 VDD VSS INV_DRV
X_final_nand_56 X_0 Y_7 WL_bar_56 VDD VSS NAND2
X_final_inv_56 WL_bar_56 WL56 VDD VSS INV_DRV
X_final_nand_57 X_1 Y_7 WL_bar_57 VDD VSS NAND2
X_final_inv_57 WL_bar_57 WL57 VDD VSS INV_DRV
X_final_nand_58 X_2 Y_7 WL_bar_58 VDD VSS NAND2
X_final_inv_58 WL_bar_58 WL58 VDD VSS INV_DRV
X_final_nand_59 X_3 Y_7 WL_bar_59 VDD VSS NAND2
X_final_inv_59 WL_bar_59 WL59 VDD VSS INV_DRV
X_final_nand_60 X_4 Y_7 WL_bar_60 VDD VSS NAND2
X_final_inv_60 WL_bar_60 WL60 VDD VSS INV_DRV
X_final_nand_61 X_5 Y_7 WL_bar_61 VDD VSS NAND2
X_final_inv_61 WL_bar_61 WL61 VDD VSS INV_DRV
X_final_nand_62 X_6 Y_7 WL_bar_62 VDD VSS NAND2
X_final_inv_62 WL_bar_62 WL62 VDD VSS INV_DRV
X_final_nand_63 X_7 Y_7 WL_bar_63 VDD VSS NAND2
X_final_inv_63 WL_bar_63 WL63 VDD VSS INV_DRV
.ENDS ROW_DECODER
